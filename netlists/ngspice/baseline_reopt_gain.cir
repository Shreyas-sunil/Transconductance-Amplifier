* Baseline topology re-optimised for maximum bandwidth at the proposed gain (fair comparison), PTM 90 nm BSIM4
* Run:  ngspice -b baseline_reopt_gain.cir
* Generated by scripts/emit.py - edit scripts/circuits.py to change the design.
.include ../../models/ptm90.lib
.param vdd=1.0 cpd=50f cout=30f lf=5.036n vg3b=0.527 vg2b=0.781 rsl=43.0
.temp 35

Vg2b g2b 0 dc {vg2b}
Vdd vdd 0 dc {vdd}
Vg3b g3b 0 dc {vg3b}
M2b n g2b vdd vdd pmos90 W=4.64u L=90n AD=0.928p AS=0.928p PD=9.68u PS=9.68u
M1 n vdd in 0 nmos90 W=1.05u L=90n AD=0.21p AS=0.21p PD=2.5u PS=2.5u
M2 in n 0 0 nmos90 W=7.22u L=90n AD=1.444p AS=1.444p PD=14.84u PS=14.84u
M3 out n 0 0 nmos90 W=1.68u L=90n AD=0.336p AS=0.336p PD=3.76u PS=3.76u
M3b out g3b vdd vdd pmos90 W=1.73u L=90n AD=0.346p AS=0.346p PD=3.86u PS=3.86u
Lf out xl {lf}
Rsl xl in {rsl}
Cpd in 0 {cpd}
Cout out 0 {cout}
Iin 0 in dc 0 ac 1

.control
set noaskquit
op
print v(in) v(out) v(n) i(vdd)
print @m2b[id] @m1[id] @m2[id] @m3[id] @m3b[id]
print @m2b[gm] @m1[gm] @m2[gm] @m3[gm] @m3b[gm]
ac dec 40 10meg 200g
let zt_db = vdb(out)
meas ac zt_100MHz find zt_db at=100meg
meas ac zt_peak max zt_db
let zt_m3 = zt_100MHz - 3
meas ac f_3dB when zt_db=zt_m3 fall=1
set wr_singlescale
wrdata baseline_reopt_gain_ac.txt vdb(out) vp(out)
noise v(out) iin dec 40 10meg 200g
setplot noise1
wrdata baseline_reopt_gain_noise.txt inoise_spectrum
.endc
.end
