* Baseline TIA - Alsheikhjader 2020 Fig. 1 as drawn (passive Lf = 2.4 nH), PTM 90 nm BSIM4
* Run:  ngspice -b baseline_tia.cir
* Generated by scripts/emit.py - edit scripts/circuits.py to change the design.
.include ../../models/ptm90.lib
.param vdd=1.0 cpd=50f cout=30f lf=2.4n vg3b=0.0
.temp 35

Vdd vdd 0 dc {vdd}
Vg3b g3b 0 dc {vg3b}
M2b n vdd vdd vdd pmos90 W=0.9u L=90n AD=0.18p AS=0.18p PD=2.2u PS=2.2u
M1 n vdd in 0 nmos90 W=5u L=90n AD=1p AS=1p PD=10.4u PS=10.4u
M2 in n 0 0 nmos90 W=5u L=90n AD=1p AS=1p PD=10.4u PS=10.4u
M3 out n 0 0 nmos90 W=5u L=90n AD=1p AS=1p PD=10.4u PS=10.4u
M3b out g3b vdd vdd pmos90 W=5u L=90n AD=1p AS=1p PD=10.4u PS=10.4u
Lf out in {lf}
Cpd in 0 {cpd}
Cout out 0 {cout}
Iin 0 in dc 0 ac 1

.control
set noaskquit
op
print v(in) v(out) v(n) i(vdd)
print @m2b[id] @m1[id] @m2[id] @m3[id] @m3b[id]
print @m2b[gm] @m1[gm] @m2[gm] @m3[gm] @m3b[gm]
ac dec 40 10meg 200g
let zt_db = vdb(out)
meas ac zt_100MHz find zt_db at=100meg
meas ac zt_peak max zt_db
let zt_m3 = zt_100MHz - 3
meas ac f_3dB when zt_db=zt_m3 fall=1
set wr_singlescale
wrdata baseline_tia_ac.txt vdb(out) vp(out)
noise v(out) iin dec 40 10meg 200g
setplot noise1
wrdata baseline_tia_noise.txt inoise_spectrum
.endc
.end
