// Proposed TIA with DC-cancellation loop (holds the follower current; set idc = average photocurrent), PTM 90 nm BSIM4
// Run:  spectre proposed_tia_dcc.scs      (results in proposed_tia_dcc.raw, open with ViVA)
// Generated by scripts/emit.py
simulator lang=spectre
global 0
include "ptm90.lib"   // SPICE-syntax PTM card; Spectre reads non-.scs includes as SPICE
parameters vdd=1.0 cpd=50f cout=30f iref=50u vtune=0.28 rn=5k rb=4.2k ca=30f cb=2p rtap=100k ctap=0.2p cint=2p idc=100u

Vdd (vdd 0) vsource dc=vdd type=dc
Vtune (vt 0) vsource dc=vtune type=dc
Iref (vbp 0) isource dc=iref type=dc
Mbp (vbp vbp vdd vdd) pmos90 w=2u l=180n as=0.4p ad=0.4p ps=4.4u pd=4.4u
Mbr (vb1 vbp vdd vdd) pmos90 w=2u l=180n as=0.4p ad=0.4p ps=4.4u pd=4.4u
Mbn (vb1 vb1 vr 0) nmos90 w=0.4u l=90n as=0.08p ad=0.08p ps=1.2u pd=1.2u
Rb (vr 0) resistor r=rb
Cb (vb1 0) capacitor c=cb
Rn (vdd n) resistor r=rn
M1 (n vb1 in 0) nmos90 w=4.5u l=90n as=0.9p ad=0.9p ps=9.4u pd=9.4u
M2 (in n 0 0) nmos90 w=3.5u l=90n as=0.7p ad=0.7p ps=7.4u pd=7.4u
M3 (out n 0 0) nmos90 w=7u l=90n as=1.4p ad=1.4p ps=14.4u pd=14.4u
M3b (out vbp vdd vdd) pmos90 w=28u l=180n as=5.6p ad=5.6p ps=56.4u pd=56.4u
Mf (vdd g in 0) nmos90 w=3.5u l=90n as=0.7p ad=0.7p ps=7.4u pd=7.4u
Mt (g vt out out) pmos90 w=12u l=90n as=2.4p ad=2.4p ps=24.4u pd=24.4u
Ca (g in) capacitor c=ca
Mq (nq vbp vdd vdd) pmos90 w=0.8u l=180n as=0.16p ad=0.16p ps=2u pd=2u
Mnq (nq nq 0 0) nmos90 w=2u l=1440n as=0.4p ad=0.4p ps=4.4u pd=4.4u
Rt1 (out to) resistor r=rtap
Ct1 (to 0) capacitor c=ctap
Rt2 (in ti) resistor r=rtap
Ct2 (ti 0) capacitor c=ctap
Mr (vdd to vrep 0) nmos90 w=1.75u l=90n as=0.35p ad=0.35p ps=3.9u pd=3.9u
Mns (vrep nq 0 0) nmos90 w=5.7u l=1440n as=1.14p ad=1.14p ps=11.8u pd=11.8u
Mtp (tp vbp vdd vdd) pmos90 w=0.4u l=720n as=0.08p ad=0.08p ps=1.2u pd=1.2u
Ma (oa ti tp vdd) pmos90 w=4u l=720n as=0.8p ad=0.8p ps=8.4u pd=8.4u
Mb (vx vrep tp vdd) pmos90 w=4u l=720n as=0.8p ad=0.8p ps=8.4u pd=8.4u
Mna (oa oa 0 0) nmos90 w=1u l=1440n as=0.2p ad=0.2p ps=2.4u pd=2.4u
Mnb (vx oa 0 0) nmos90 w=1u l=1440n as=0.2p ad=0.2p ps=2.4u pd=2.4u
Cint (vx 0) capacitor c=cint
Mdc (in vx 0 0) nmos90 w=6u l=180n as=1.2p ad=1.2p ps=12.4u pd=12.4u
Cpd (in 0) capacitor c=cpd
Cout (out 0) capacitor c=cout
Iin (0 in) isource dc=idc type=dc mag=1

simOpts options temp=35 tnom=27 reltol=1e-4 vabstol=1e-6 iabstol=1e-12 save=allpub
dcOp dc oppoint=logfile
dcOpInfo info what=oppoint where=rawfile
acZt ac start=10M stop=200G dec=40
noiseIn (out 0) noise start=10M stop=200G dec=40 iprobe=Iin
// average-photocurrent sweep: the DC-cancellation loop holds the bandwidth
swIdc sweep param=idc values=[0 100u 300u 500u] {
    acIdc ac start=1k stop=200G dec=20
}
// photocurrent step 0 -> 200 uA -> 0 on top of idc: settling of the cancellation loop
Istep (0 in) isource type=pwl wave=[0 0 1u 0 1.001u 200u 6u 200u 6.001u 0]
tranStep tran stop=11u maxstep=2n
