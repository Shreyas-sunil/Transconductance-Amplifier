// Baseline TIA - Alsheikhjader 2020 Fig. 1 as drawn (passive Lf = 2.4 nH), PTM 90 nm BSIM4
// Run:  spectre baseline_tia.scs      (results in baseline_tia.raw, open with ViVA)
// Generated by scripts/emit.py
simulator lang=spectre
global 0
include "ptm90.lib"   // SPICE-syntax PTM card; Spectre reads non-.scs includes as SPICE
parameters vdd=1.0 cpd=50f cout=30f lf=2.4n vg3b=0.0

Vdd (vdd 0) vsource dc=vdd type=dc
Vg3b (g3b 0) vsource dc=vg3b type=dc
M2b (n vdd vdd vdd) pmos90 w=0.9u l=90n as=0.18p ad=0.18p ps=2.2u pd=2.2u
M1 (n vdd in 0) nmos90 w=5u l=90n as=1p ad=1p ps=10.4u pd=10.4u
M2 (in n 0 0) nmos90 w=5u l=90n as=1p ad=1p ps=10.4u pd=10.4u
M3 (out n 0 0) nmos90 w=5u l=90n as=1p ad=1p ps=10.4u pd=10.4u
M3b (out g3b vdd vdd) pmos90 w=5u l=90n as=1p ad=1p ps=10.4u pd=10.4u
Lf (out in) inductor l=lf
Cpd (in 0) capacitor c=cpd
Cout (out 0) capacitor c=cout
Iin (0 in) isource dc=0 type=dc mag=1

simOpts options temp=35 tnom=27 reltol=1e-4 vabstol=1e-6 iabstol=1e-12 save=allpub
dcOp dc oppoint=logfile
dcOpInfo info what=oppoint where=rawfile
acZt ac start=10M stop=200G dec=40
noiseIn (out 0) noise start=10M stop=200G dec=40 iprobe=Iin
