// Baseline topology re-optimised for maximum bandwidth at the proposed gain (fair comparison), PTM 90 nm BSIM4
// Run:  spectre baseline_reopt_gain.scs      (results in baseline_reopt_gain.raw, open with ViVA)
// Generated by scripts/emit.py
simulator lang=spectre
global 0
include "ptm90.lib"   // SPICE-syntax PTM card; Spectre reads non-.scs includes as SPICE
parameters vdd=1.0 cpd=50f cout=30f lf=5.036n vg3b=0.527 vg2b=0.781 rsl=43.0

Vg2b (g2b 0) vsource dc=vg2b type=dc
Vdd (vdd 0) vsource dc=vdd type=dc
Vg3b (g3b 0) vsource dc=vg3b type=dc
M2b (n g2b vdd vdd) pmos90 w=4.64u l=90n as=0.928p ad=0.928p ps=9.68u pd=9.68u
M1 (n vdd in 0) nmos90 w=1.05u l=90n as=0.21p ad=0.21p ps=2.5u pd=2.5u
M2 (in n 0 0) nmos90 w=7.22u l=90n as=1.444p ad=1.444p ps=14.84u pd=14.84u
M3 (out n 0 0) nmos90 w=1.68u l=90n as=0.336p ad=0.336p ps=3.76u pd=3.76u
M3b (out g3b vdd vdd) pmos90 w=1.73u l=90n as=0.346p ad=0.346p ps=3.86u pd=3.86u
Lf (out xl) inductor l=lf
Rsl (xl in) resistor r=rsl
Cpd (in 0) capacitor c=cpd
Cout (out 0) capacitor c=cout
Iin (0 in) isource dc=0 type=dc mag=1

simOpts options temp=35 tnom=27 reltol=1e-4 vabstol=1e-6 iabstol=1e-12 save=allpub
dcOp dc oppoint=logfile
dcOpInfo info what=oppoint where=rawfile
acZt ac start=10M stop=200G dec=40
noiseIn (out 0) noise start=10M stop=200G dec=40 iprobe=Iin
