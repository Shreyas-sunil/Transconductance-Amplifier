// A4_proposed_single_booster_fvf_cm - testbench A_dc
// Cadence Spectre, gpdk090 (nmos1v/pmos1v). Device sizes are the PTM90 design copied over;
// re-tune bias/sizes in GPDK090 before quoting numbers (thresholds differ).
simulator lang=spectre
global 0
include "/home/buet/cadence/gpdk090_v4.6/models/spectre/gpdk090.scs" section=NN
Vdd (vdd 0) vsource dc=1
Vcn (vcn 0) vsource dc=0.42
Vo (out 0) vsource dc=0.5
Ibf (vdd y) isource dc=2e-06
M1C (y G1 x 0) nmos1v w=40u l=360n
M1 (x y 0 0) nmos1v w=10u l=360n
Vjoin (inn x) vsource dc=0
M2C (out G2 x2 0) nmos1v w=40u l=360n
M2 (x2 y 0 0) nmos1v w=10u l=360n
Ibo (vdd out) isource dc=2e-06
Vg1 (G1 0) vsource dc=0.42
It (vdd tl) isource dc=2e-07
MPa (da x tl vdd) pmos1v w=0.25u l=1u
MPb (G2 x2 tl vdd) pmos1v w=0.25u l=1u
MNa (da da 0 0) nmos1v w=1u l=360n
MNb (G2 da 0 0) nmos1v w=1u l=360n
Cc2 (G2 0) capacitor c=0.3p
Iin (0 inn) isource dc=10u mag=1
simOpts options temp=27 tnom=27 reltol=1e-5 gmin=1e-15
dcop dc
dcIin dc dev=Iin param=dc start=0 stop=20u step=0.25u
acRin ac start=1k stop=10G dec=40
dcVo dc dev=Vo param=dc start=0 stop=1 step=5m
