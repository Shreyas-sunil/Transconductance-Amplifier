* A3_base_hp_fvf_cm_reconstruction - testbench A_dc
* LTspice, PTM 90 nm BSIM4. Open in LTspice and Run. If LTspice rejects 'level = 54' in ptm90.lib, change it to 'level = 14' (both are BSIM4).
.include ptm90.lib
Vdd vdd 0 1
Vcn vcn 0 0.42
Vo out 0 dc 0.5 ac 0
Ibf vdd y 2e-06
M1C y G1 x 0 nmos90 W=40u L=360n
M1 x y 0 0 nmos90 W=10u L=360n
Vjoin inn x 0
M2C out G2 x2 0 nmos90 W=40u L=360n
M2 x2 y 0 0 nmos90 W=10u L=360n
Ibo vdd out 2e-06
Ia1 vdd G1 2e-07
Ia2 vdd G2 2e-07
MA1 G1 x 0 0 nmos90 W=2u L=360n
MA2 G2 x2 0 0 nmos90 W=2u L=360n
Cc1 G1 0 0.3p
Cc2 G2 0 0.3p
Iin 0 inn dc 10u ac 1
.dc Iin 0 20u 0.25u
* for input resistance / bandwidth use instead:  .ac dec 40 1k 10G   (Rin = V(inn) per 1 A, BW from I(Vo))
* for output compliance / Rout use instead:     .dc Vo 0 1 5m
.backanno
.end
