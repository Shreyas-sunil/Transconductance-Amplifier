* A6_proposed_dem_mirror_chopped - testbench A_chop
* PTM 90 nm BSIM4 (ptm90.lib). Run: ngspice -b <file>
.include ptm90.lib
Vdd vdd 0 1
Vcn vcn 0 0.42
Vo out 0 dc 0.5 ac 0
Ibf vdd y 2e-06
M1C y G1 x 0 nmos90 W=10u L=360n
MA da y 0 0 nmos90 W=10u L=360n
Vjoin inn x 0
M2C out G2 x2 0 nmos90 W=10u L=360n
MB db y 0 0 nmos90 W=10u L=360n
Ibo vdd out 2e-06
Ia1 vdd G1 2e-07
Ia2 vdd G2 2e-07
MA1 a1 x 0 0 nmos90 W=8u L=360n
MA2 a2 x2 0 0 nmos90 W=8u L=360n
Cc1 G1 0 0.3p
Cc2 G2 0 0.3p
Vcb vcb 0 0.45
MK1 G1 vcb a1 0 nmos90 W=2u L=360n
MK2 G2 vcb a2 0 nmos90 W=2u L=360n
Vp1 p1 0 pulse(0 1 0 1e-09 1e-09 9.9900e-07 2.0000e-06)
Vp2 p2 0 pulse(1 0 0 1e-09 1e-09 9.9900e-07 2.0000e-06)
MS1 da p1 x 0 nmos90 W=4u L=0.1u
MS2 db p1 x2 0 nmos90 W=4u L=0.1u
MS3 da p2 x2 0 nmos90 W=4u L=0.1u
MS4 db p2 x 0 nmos90 W=4u L=0.1u
Iin 0 inn dc 10u
.control
tran 5n 20u 0 5n uic
let iout=-i(Vo)
meas tran Iout_avg avg iout from=8u to=20u
meas tran Vin_avg avg v(inn) from=8u to=20u
wrdata chop_out.txt iout v(inn)
.endc
.end
