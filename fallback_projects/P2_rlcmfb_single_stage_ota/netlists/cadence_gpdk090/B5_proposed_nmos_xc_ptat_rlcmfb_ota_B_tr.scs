// B5_proposed_nmos_xc_ptat_rlcmfb_ota - testbench B_tr
// Cadence Spectre, gpdk090 (nmos1v/pmos1v). Device sizes are the PTM90 design copied over;
// re-tune bias/sizes in GPDK090 before quoting numbers (thresholds differ).
simulator lang=spectre
global 0
include "/home/buet/cadence/gpdk090_v4.6/models/spectre/gpdk090.scs" section=NN
Vdd (vdd 0) vsource dc=0.45
Vss (vss 0) vsource dc=-0.45
// bias: 2.5uA reference into NMOS diode
Ib (vdd nb) isource dc=2.5u
Mb (nb nb vss vss) nmos1v w=10u l=180n
M0 (t nb vss vss) nmos1v w=20u l=180n
M1 (a inn t vss) nmos1v w=10u l=180n
M2 (b inp t vss) nmos1v w=10u l=180n
M3 (a cm vdd vdd) pmos1v w=10u l=180n
M4 (b cm vdd vdd) pmos1v w=10u l=180n
Mx3 (a b tx vss) nmos1v w=2u l=180n
Mx4 (b a tx vss) nmos1v w=2u l=180n
Ra (a cm) resistor r=150k
Rb (b cm) resistor r=150k
M3P (out b vdd vdd) pmos1v w=10u l=180n
M4P (c a vdd vdd) pmos1v w=10u l=180n
M5 (c c vss vss) nmos1v w=10u l=180n
M6 (out c vss vss) nmos1v w=10u l=180n
MPa (ga gp vdd vdd) pmos1v w=8u l=4u
MPb (gp gp vdd vdd) pmos1v w=8u l=4u
MRa (ga ga vss vss) nmos1v w=8u l=4u
MRb (gp ga sr vss) nmos1v w=8u l=4u m=8
Rp (sr vss) resistor r=260k
Mtx (tx ga vss vss) nmos1v w=8u l=4u m=2
MSU (gp vss vss vss) nmos1v w=0.12u l=4u
Rs (out o2) resistor r=5k
Vml (o2 oL) vsource dc=0
Cl (oL 0) capacitor c=2p
Vin (inp 0) vsource type=pulse dc=-0.2 val0=-0.2 val1=0.2 delay=20n rise=1n fall=1n width=399n period=800n
Vsh (inn out) vsource dc=0
simOpts options temp=27 tnom=27 reltol=1e-5 gmin=1e-15
tr tran stop=900n maxstep=0.2n
