* B5_proposed_nmos_xc_ptat_rlcmfb_ota - testbench B_ac
* LTspice, PTM 90 nm BSIM4. Open in LTspice and Run. If LTspice rejects 'level = 54' in ptm90.lib, change it to 'level = 14' (both are BSIM4).
.include ptm90.lib
Vdd vdd 0 0.45
Vss vss 0 -0.45
* bias: 2.5uA reference into NMOS diode
Ib vdd nb 2.5u
Mb nb nb vss vss nmos90 W=10u L=180n
M0 t nb vss vss nmos90 W=20u L=180n
M1 a inn t vss nmos90 W=10u L=180n
M2 b inp t vss nmos90 W=10u L=180n
M3 a cm vdd vdd pmos90 W=10u L=180n
M4 b cm vdd vdd pmos90 W=10u L=180n
Mx3 a b tx vss nmos90 W=2u L=180n
Mx4 b a tx vss nmos90 W=2u L=180n
Ra a cm 150k
Rb b cm 150k
M3P out b vdd vdd pmos90 W=10u L=180n
M4P c a vdd vdd pmos90 W=10u L=180n
M5 c c vss vss nmos90 W=10u L=180n
M6 out c vss vss nmos90 W=10u L=180n
MPa ga gp vdd vdd pmos90 W=8u L=4u
MPb gp gp vdd vdd pmos90 W=8u L=4u
MRa ga ga vss vss nmos90 W=8u L=4u
MRb gp ga sr vss nmos90 W=8u L=4u m=8
Rp sr vss 260k
Mtx tx ga vss vss nmos90 W=8u L=4u m=2
MSU gp vss vss vss nmos90 W=0.12u L=4u
Rs out o2 5k
Vml o2 oL 0
Cl oL 0 2p
Rf out inn 100Meg
Cf inn 0 1
Vin inp 0 dc 0 ac 1
.ac dec 50 1 10G
.meas AC A0_dB FIND dB(V(out)) AT=10
.meas AC UGF WHEN mag(V(out))=1
.meas AC PH_UGF FIND ph(V(out)) WHEN mag(V(out))=1
.backanno
.end
