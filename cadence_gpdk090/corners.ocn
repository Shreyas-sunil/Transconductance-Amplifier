; GPDK090 corners x temperature: AC transimpedance + supply current. Proposed TIA at Vtune = 0.24 V.
out = outfile("/home/buet/cds_work/tia_gpdk090/corners_summary.txt")
foreach(cell list("TIA_2020_base_gpdk090" "TIA_2020_regain_gpdk090" "TIA_proposed_v1_gpdk090")
  simulator('spectre)
  design("TIA_Proj" cell "schematic")
  resultsDir(strcat("/home/buet/cds_work/tia_gpdk090/sim_c_" cell))
  analysis('dc ?saveOppoint t)
  analysis('ac ?start "10M" ?stop "200G" ?dec "40")
  save('v "/out" "/in")
  desVar("vtn" 0.24)
  foreach(sec list("NN" "SS" "FF" "FS" "SF")
    modelFile(list("/home/buet/cadence/gpdk090_v4.6/models/spectre/gpdk090.scs" sec))
    foreach(tp list(-40 35 125)
      temp(tp)
      run()
      zt = mag(VF("/out"))
      z100 = value(zt 1e8)
      selectResult('dcOp)
      idd = getData("/Vdd/PLUS")
      selectResult('ac)
      fprintf(out "%s %s %d Zt=%.2f pk=%.2f f3dB=%L Idd=%L\n" cell sec tp 20*log10(z100) 20*log10(ymax(zt)) cross(zt z100/sqrt(2) 1 "falling") idd)
    )
  )
)
close(out)
exit()
