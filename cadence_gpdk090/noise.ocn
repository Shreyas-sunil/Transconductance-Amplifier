; GPDK090 input-referred current noise at NN / 35 C (proposed at Vtune = 0.24 V).
out = outfile("/home/buet/cds_work/tia_gpdk090/noise_summary.txt")
foreach(cell list("TIA_2020_base_gpdk090" "TIA_2020_regain_gpdk090" "TIA_proposed_v1_gpdk090")
  simulator('spectre)
  design("TIA_Proj" cell "schematic")
  resultsDir(strcat("/home/buet/cds_work/tia_gpdk090/sim_n_" cell))
  modelFile('("/home/buet/cadence/gpdk090_v4.6/models/spectre/gpdk090.scs" "NN"))
  temp(35)
  desVar("vtn" 0.24)
  analysis('noise ?start "10M" ?stop "10G" ?dec "20" ?p "/out" ?n "0" ?iprobe "/Iin")
  run()
  selectResult('noise)
  inz = getData("in" ?result "noise")
  fprintf(out "%s in@1G=%L in@5G=%L in@10G=%L irms=%L\n" cell value(inz 1e9) value(inz 5e9) value(inz 1e10) sqrt(value(integ(inz*inz) 1e10)))
)
close(out)
exit()
