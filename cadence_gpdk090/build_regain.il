procedure(tI(cv lib cell name x y ori params)
  let((m) m=dbOpenCellViewByType(lib cell "symbol")
    unless(m error("no master %s %s" lib cell))
    dbCreateParamInst(cv m name list(x y) ori 1 params)))
procedure(tW(cv pts)
  let((i) i=0
    while(i < length(pts)-1
      schCreateWire(cv "draw" "full" list(nth(i pts) nth(i+1 pts)) 0.0625 0.0625 0.0)
      i=i+1)))
procedure(tL(cv name pts)
  let((w p1 p2) w=car(schCreateWire(cv "draw" "full" pts 0.0625 0.0625 0.0))
    p1=car(pts) p2=cadr(pts)
    schCreateWireLabel(cv w list((xCoord(p1)+xCoord(p2))/2.0 (yCoord(p1)+yCoord(p2))/2.0+0.03)
       name "lowerCenter" "R0" "stick" 0.0625 nil)))
procedure(tG(cv x y) dbCreateInst(cv dbOpenCellViewByType("analogLib" "gnd" "symbol") nil list(x y) "R0"))
procedure(tV(cv x y) dbCreateInst(cv dbOpenCellViewByType("analogLib" "vdd" "symbol") nil list(x y) "R0"))
procedure(tNote(cv x y txt h)
  dbCreateLabel(cv list("text" "drawing") list(x y) txt "lowerLeft" "R0" "stick" h))
procedure(tiaBuild_TIA_2020_regain_gpdk090(lib)
 let((cv)
  cv=dbOpenCellViewByType(lib "TIA_2020_regain_gpdk090" "schematic" "schematic" "w")
  tI(cv "gpdk090" "pmos1v" "M2b" 0.5 2.5 "R0" list(list("w" "string" "4.64u") list("fw" "string" "4.64u") list("l" "string" "100n") list("fingers" "string" "1") list("m" "string" "1") list("ad" "string" "2.691p") list("as" "string" "2.691p") list("pd" "string" "10.44u") list("ps" "string" "10.44u")))
  tW(cv list(list(0.75 2.6875) list(0.75 2.75)))
  tW(cv list(list(0.75 2.75) list(0.75 2.875)))
  tV(cv 0.75 2.875)
  tL(cv "g2b" list(list(0.5 2.5) list(0.0 2.5)))
  tW(cv list(list(0.0 2.5) list(-0.25 2.5) list(-0.25 2.25)))
  tI(cv "analogLib" "vdc" "Vg2b" -0.25 2.25 "R0" list(list("vdc" "string" "0.781")))
  tG(cv -0.25 1.875)
  tW(cv list(list(0.75 2.5) list(1.0 2.5) list(1.0 2.75) list(0.75 2.75)))
  tI(cv "gpdk090" "nmos1v" "M1" 0.5 1.75 "R0" list(list("w" "string" "1.05u") list("fw" "string" "1.05u") list("l" "string" "100n") list("fingers" "string" "1") list("m" "string" "1") list("ad" "string" "0.609p") list("as" "string" "0.609p") list("pd" "string" "3.26u") list("ps" "string" "3.26u")))
  tW(cv list(list(0.75 1.9375) list(0.75 2.125)))
  tW(cv list(list(0.75 2.125) list(0.75 2.3125)))
  tW(cv list(list(0.5 1.75) list(0.125 1.75) list(0.125 1.9375)))
  tV(cv 0.125 1.9375)
  tW(cv list(list(0.75 1.75) list(1.0 1.75)))
  tG(cv 1.0 1.75)
  tW(cv list(list(0.75 1.5625) list(0.75 1.25)))
  tW(cv list(list(0.75 1.25) list(0.75 0.9375)))
  tI(cv "gpdk090" "nmos1v" "M2" 1.0 0.75 "MY" list(list("w" "string" "7.22u") list("fw" "string" "7.22u") list("l" "string" "100n") list("fingers" "string" "1") list("m" "string" "1") list("ad" "string" "4.188p") list("as" "string" "4.188p") list("pd" "string" "15.6u") list("ps" "string" "15.6u")))
  tG(cv 0.75 0.5625)
  tW(cv list(list(0.75 0.75) list(0.5 0.75)))
  tG(cv 0.5 0.75)
  tL(cv "n" list(list(0.75 2.125) list(1.5 2.125)))
  tW(cv list(list(1.5 2.125) list(1.5 0.75)))
  tW(cv list(list(1.5 0.75) list(1.0 0.75)))
  tW(cv list(list(1.5 0.75) list(2.5 0.75)))
  tI(cv "gpdk090" "nmos1v" "M3" 2.5 0.75 "R0" list(list("w" "string" "1.68u") list("fw" "string" "1.68u") list("l" "string" "100n") list("fingers" "string" "1") list("m" "string" "1") list("ad" "string" "0.9744p") list("as" "string" "0.9744p") list("pd" "string" "4.52u") list("ps" "string" "4.52u")))
  tG(cv 2.75 0.5625)
  tW(cv list(list(2.75 0.75) list(3.0 0.75)))
  tG(cv 3.0 0.75)
  tI(cv "gpdk090" "pmos1v" "M3b" 2.5 2.5 "R0" list(list("w" "string" "1.73u") list("fw" "string" "1.73u") list("l" "string" "100n") list("fingers" "string" "1") list("m" "string" "1") list("ad" "string" "1.003p") list("as" "string" "1.003p") list("pd" "string" "4.62u") list("ps" "string" "4.62u")))
  tV(cv 2.75 2.6875)
  tW(cv list(list(2.75 2.5) list(3.0 2.5) list(3.0 2.875)))
  tV(cv 3.0 2.875)
  tL(cv "g3b" list(list(2.5 2.5) list(2.0 2.5)))
  tW(cv list(list(2.0 2.5) list(2.0 2.25)))
  tI(cv "analogLib" "vdc" "Vg3b" 2.0 2.25 "R0" list(list("vdc" "string" "0.527")))
  tG(cv 2.0 1.875)
  tW(cv list(list(2.75 2.3125) list(2.75 1.625)))
  tW(cv list(list(2.75 1.625) list(2.75 0.9375)))
  tL(cv "out" list(list(2.75 1.625) list(3.75 1.625)))
  tW(cv list(list(3.75 1.625) list(3.75 1.25)))
  tW(cv list(list(3.75 1.625) list(4.5 1.625)))
  tI(cv "analogLib" "cap" "Cout" 3.75 1.25 "R0" list(list("c" "string" "30f")))
  tG(cv 3.75 0.875)
  tI(cv "analogLib" "ind" "Lf" 1.5 3.375 "R90" list(list("l" "string" "5.036n")))
  tW(cv list(list(4.5 1.625) list(4.5 3.375) list(1.875 3.375)))
  tI(cv "analogLib" "res" "Rsl" 0.75 3.375 "R90" list(list("r" "string" "43")))
  tW(cv list(list(1.125 3.375) list(1.5 3.375)))
  tW(cv list(list(0.75 3.375) list(-0.375 3.375) list(-0.375 1.25)))
  tL(cv "in" list(list(-0.375 1.25) list(0.75 1.25)))
  tW(cv list(list(-0.375 1.25) list(-1.0 1.25)))
  tI(cv "analogLib" "cap" "Cpd" -1.0 1.25 "R0" list(list("c" "string" "50f")))
  tG(cv -1.0 0.875)
  tW(cv list(list(-1.0 1.25) list(-1.75 1.25)))
  tI(cv "analogLib" "idc" "Iin" -1.75 0.875 "R180" list(list("idc" "string" "0") list("acm" "string" "1")))
  tG(cv -1.75 0.875)
  tI(cv "analogLib" "vdc" "Vdd" -2.75 1.25 "R0" list(list("vdc" "string" "1")))
  tW(cv list(list(-2.75 1.25) list(-2.75 1.5)))
  tV(cv -2.75 1.5)
  tG(cv -2.75 0.875)
  tNote(cv -2.75 4.0 "2020 TIA topology re-optimised for the proposed gain (same-gain baseline) - GPDK090, VDD = 1 V" 0.12)
  tNote(cv -2.75 3.8 "Sizes from the LTspice/PTM re-optimisation; L = 100 nm. M2b gate on Vg2b, Rsl = 43 ohm in series with Lf = 5.036 nH." 0.08)
  schCheck(cv)
  printf("BUILT TIA_2020_regain_gpdk090: errors/warnings %L\n" schCheck(cv))
  dbSave(cv)
  dbClose(cv)
  t))
tiaBuild_TIA_2020_regain_gpdk090("TIA_Proj")
