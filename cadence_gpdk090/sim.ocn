; Netlists each GPDK090 schematic from Virtuoso and runs Spectre (NN, 35 C): DC op + AC transimpedance.
out = outfile("/home/buet/cds_work/tia_gpdk090/sim_summary.txt")
foreach(cell list("TIA_2020_base_gpdk090" "TIA_proposed_v1_gpdk090")
  simulator('spectre)
  design("TIA_Proj" cell "schematic")
  resultsDir(strcat("/home/buet/cds_work/tia_gpdk090/sim_" cell))
  modelFile('("/home/buet/cadence/gpdk090_v4.6/models/spectre/gpdk090.scs" "NN"))
  temp(35)
  analysis('dc ?saveOppoint t)
  analysis('ac ?start "10M" ?stop "200G" ?dec "40")
  save('v "/out" "/in" "/n")
  run()
  zt = mag(VF("/out"))
  z100 = value(zt 1e8)
  bw = cross(zt z100/sqrt(2) 1 "falling")
  pk = ymax(zt)
  selectResult('dcOp)
  idd = getData("/Vdd/PLUS")
  fprintf(out "%s  Zt(100MHz)=%.2f dBohm  peak=%.2f dBohm  f3dB=%L Hz  Idd=%L A\n"
     cell 20*log10(z100) 20*log10(pk) bw idd)
  fprintf(out "   V(in)=%L V(n)=%L V(out)=%L\n" getData("/in") getData("/n") getData("/out"))
)
close(out)
exit()
