; GPDK090 proposed TIA: Vtune sweep, then noise and corner runs at the best Vtune.
simulator('spectre)
design("TIA_Proj" "TIA_proposed_v1_gpdk090" "schematic")
resultsDir("/home/buet/cds_work/tia_gpdk090/sim_sweep")
temp(35)
out = outfile("/home/buet/cds_work/tia_gpdk090/sweep_summary.txt")
modelFile('("/home/buet/cadence/gpdk090_v4.6/models/spectre/gpdk090.scs" "NN"))
analysis('ac ?start "10M" ?stop "200G" ?dec "40")
save('v "/out" "/in")
foreach(vt list(0.20 0.22 0.24 0.26 0.28 0.30 0.32 0.34 0.36 0.40)
  desVar("vtn" vt)
  run()
  zt = mag(VF("/out"))
  z100 = value(zt 1e8)
  bw = cross(zt z100/sqrt(2) 1 "falling")
  fprintf(out "NN vtn=%.2f Zt=%.2f dBohm peak=%.2f dBohm f3dB=%L\n" vt 20*log10(z100) 20*log10(ymax(zt)) bw)
)
close(out)
exit()
