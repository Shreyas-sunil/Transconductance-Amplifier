;; Builds GPDK090 schematics of the 2020 base TIA and the proposed TIA v1 in a library.

procedure(tI(cv lib cell name x y ori params)
  let((m) m=dbOpenCellViewByType(lib cell "symbol")
    unless(m error("no master %s %s" lib cell))
    dbCreateParamInst(cv m name list(x y) ori 1 params)))
procedure(tW(cv pts)
  let((i) i=0
    while(i < length(pts)-1
      schCreateWire(cv "draw" "full" list(nth(i pts) nth(i+1 pts)) 0.0625 0.0625 0.0)
      i=i+1)))
procedure(tL(cv name pts)
  let((w p1 p2) w=car(schCreateWire(cv "draw" "full" pts 0.0625 0.0625 0.0))
    p1=car(pts) p2=cadr(pts)
    schCreateWireLabel(cv w list((xCoord(p1)+xCoord(p2))/2.0 (yCoord(p1)+yCoord(p2))/2.0+0.03)
       name "lowerCenter" "R0" "stick" 0.0625 nil)))
procedure(tG(cv x y) dbCreateInst(cv dbOpenCellViewByType("analogLib" "gnd" "symbol") nil list(x y) "R0"))
procedure(tV(cv x y) dbCreateInst(cv dbOpenCellViewByType("analogLib" "vdd" "symbol") nil list(x y) "R0"))
procedure(tNote(cv x y txt h)
  dbCreateLabel(cv list("text" "drawing") list(x y) txt "lowerLeft" "R0" "stick" h))
procedure(tiaBuild_TIA_2020_base_gpdk090(lib)
 let((cv)
  cv=dbOpenCellViewByType(lib "TIA_2020_base_gpdk090" "schematic" "schematic" "w")
  tI(cv "gpdk090" "pmos1v" "M2b" 0.5 2.5 "R0" list(list("w" "string" "0.9u") list("fw" "string" "0.9u") list("l" "string" "100n") list("fingers" "string" "1") list("m" "string" "1") list("ad" "string" "0.522p") list("as" "string" "0.522p") list("pd" "string" "2.96u") list("ps" "string" "2.96u")))
  tW(cv list(list(0.75 2.6875) list(0.75 2.75)))
  tW(cv list(list(0.75 2.75) list(0.75 2.875)))
  tV(cv 0.75 2.875)
  tW(cv list(list(0.5 2.5) list(0.125 2.5) list(0.125 2.875)))
  tV(cv 0.125 2.875)
  tW(cv list(list(0.75 2.5) list(1.0 2.5) list(1.0 2.75) list(0.75 2.75)))
  tI(cv "gpdk090" "nmos1v" "M1" 0.5 1.75 "R0" list(list("w" "string" "5u") list("fw" "string" "5u") list("l" "string" "100n") list("fingers" "string" "1") list("m" "string" "1") list("ad" "string" "2.9p") list("as" "string" "2.9p") list("pd" "string" "11.16u") list("ps" "string" "11.16u")))
  tW(cv list(list(0.75 1.9375) list(0.75 2.125)))
  tW(cv list(list(0.75 2.125) list(0.75 2.3125)))
  tW(cv list(list(0.5 1.75) list(0.125 1.75) list(0.125 1.9375)))
  tV(cv 0.125 1.9375)
  tW(cv list(list(0.75 1.75) list(1.0 1.75)))
  tG(cv 1.0 1.75)
  tW(cv list(list(0.75 1.5625) list(0.75 1.25)))
  tW(cv list(list(0.75 1.25) list(0.75 0.9375)))
  tI(cv "gpdk090" "nmos1v" "M2" 1.0 0.75 "MY" list(list("w" "string" "5u") list("fw" "string" "5u") list("l" "string" "100n") list("fingers" "string" "1") list("m" "string" "1") list("ad" "string" "2.9p") list("as" "string" "2.9p") list("pd" "string" "11.16u") list("ps" "string" "11.16u")))
  tG(cv 0.75 0.5625)
  tW(cv list(list(0.75 0.75) list(0.5 0.75)))
  tG(cv 0.5 0.75)
  tL(cv "n" list(list(0.75 2.125) list(1.5 2.125)))
  tW(cv list(list(1.5 2.125) list(1.5 0.75)))
  tW(cv list(list(1.5 0.75) list(1.0 0.75)))
  tW(cv list(list(1.5 0.75) list(2.5 0.75)))
  tI(cv "gpdk090" "nmos1v" "M3" 2.5 0.75 "R0" list(list("w" "string" "5u") list("fw" "string" "5u") list("l" "string" "100n") list("fingers" "string" "1") list("m" "string" "1") list("ad" "string" "2.9p") list("as" "string" "2.9p") list("pd" "string" "11.16u") list("ps" "string" "11.16u")))
  tG(cv 2.75 0.5625)
  tW(cv list(list(2.75 0.75) list(3.0 0.75)))
  tG(cv 3.0 0.75)
  tI(cv "gpdk090" "pmos1v" "M3b" 2.5 2.5 "R0" list(list("w" "string" "5u") list("fw" "string" "5u") list("l" "string" "100n") list("fingers" "string" "1") list("m" "string" "1") list("ad" "string" "2.9p") list("as" "string" "2.9p") list("pd" "string" "11.16u") list("ps" "string" "11.16u")))
  tV(cv 2.75 2.6875)
  tW(cv list(list(2.75 2.5) list(3.0 2.5) list(3.0 2.875)))
  tV(cv 3.0 2.875)
  tL(cv "g3b" list(list(2.5 2.5) list(2.0 2.5)))
  tW(cv list(list(2.0 2.5) list(2.0 2.25)))
  tI(cv "analogLib" "vdc" "Vg3b" 2.0 2.25 "R0" list(list("vdc" "string" "0")))
  tG(cv 2.0 1.875)
  tW(cv list(list(2.75 2.3125) list(2.75 1.625)))
  tW(cv list(list(2.75 1.625) list(2.75 0.9375)))
  tL(cv "out" list(list(2.75 1.625) list(3.75 1.625)))
  tW(cv list(list(3.75 1.625) list(3.75 1.25)))
  tW(cv list(list(3.75 1.625) list(4.5 1.625)))
  tI(cv "analogLib" "cap" "Cout" 3.75 1.25 "R0" list(list("c" "string" "30f")))
  tG(cv 3.75 0.875)
  tI(cv "analogLib" "ind" "Lf" 1.5 3.375 "R90" list(list("l" "string" "2.4n")))
  tW(cv list(list(4.5 1.625) list(4.5 3.375) list(1.875 3.375)))
  tW(cv list(list(1.5 3.375) list(-0.375 3.375) list(-0.375 1.25)))
  tL(cv "in" list(list(-0.375 1.25) list(0.75 1.25)))
  tW(cv list(list(-0.375 1.25) list(-1.0 1.25)))
  tI(cv "analogLib" "cap" "Cpd" -1.0 1.25 "R0" list(list("c" "string" "50f")))
  tG(cv -1.0 0.875)
  tW(cv list(list(-1.0 1.25) list(-1.75 1.25)))
  tI(cv "analogLib" "idc" "Iin" -1.75 0.875 "R180" list(list("idc" "string" "0") list("acm" "string" "1")))
  tG(cv -1.75 0.875)
  tI(cv "analogLib" "vdc" "Vdd" -2.75 1.25 "R0" list(list("vdc" "string" "1")))
  tW(cv list(list(-2.75 1.25) list(-2.75 1.5)))
  tV(cv -2.75 1.5)
  tG(cv -2.75 0.875)
  tNote(cv -2.75 4.0 "2020 current-mirror TIA as published (Alsheikhjader 2020, Fig. 1) - GPDK090, VDD = 1 V" 0.12)
  tNote(cv -2.75 3.8 "M1 and M2b gates tied to VDD as drawn in the paper. L = 100 nm (GPDK090 minimum; paper used 90 nm)." 0.08)
  tNote(cv -2.75 3.65 "Iin: AC 1 A photodiode current, Cpd = 50 fF, CL = 30 fF, Lf = 2.4 nH ideal spiral" 0.08)
  schCheck(cv)
  printf("BUILT TIA_2020_base_gpdk090: errors/warnings %L\n" schCheck(cv))
  dbSave(cv)
  dbClose(cv)
  t))
procedure(tiaBuild_TIA_proposed_v1_gpdk090(lib)
 let((cv)
  cv=dbOpenCellViewByType(lib "TIA_proposed_v1_gpdk090" "schematic" "schematic" "w")
  tI(cv "analogLib" "res" "Rn" 0.75 2.6875 "R0" list(list("r" "string" "5k")))
  tW(cv list(list(0.75 2.6875) list(0.75 2.875)))
  tV(cv 0.75 2.875)
  tI(cv "gpdk090" "nmos1v" "M1" 0.5 1.75 "R0" list(list("w" "string" "4.5u") list("fw" "string" "4.5u") list("l" "string" "100n") list("fingers" "string" "1") list("m" "string" "1") list("ad" "string" "2.61p") list("as" "string" "2.61p") list("pd" "string" "10.16u") list("ps" "string" "10.16u")))
  tW(cv list(list(0.75 1.9375) list(0.75 2.125)))
  tW(cv list(list(0.75 2.125) list(0.75 2.3125)))
  tL(cv "vb1" list(list(0.5 1.75) list(0.125 1.75)))
  tW(cv list(list(0.75 1.75) list(1.0 1.75)))
  tG(cv 1.0 1.75)
  tW(cv list(list(0.75 1.5625) list(0.75 1.25)))
  tW(cv list(list(0.75 1.25) list(0.75 0.9375)))
  tI(cv "gpdk090" "nmos1v" "M2" 1.0 0.75 "MY" list(list("w" "string" "3.5u") list("fw" "string" "3.5u") list("l" "string" "100n") list("fingers" "string" "1") list("m" "string" "1") list("ad" "string" "2.03p") list("as" "string" "2.03p") list("pd" "string" "8.16u") list("ps" "string" "8.16u")))
  tG(cv 0.75 0.5625)
  tW(cv list(list(0.75 0.75) list(0.5 0.75)))
  tG(cv 0.5 0.75)
  tL(cv "n" list(list(0.75 2.125) list(1.5 2.125)))
  tW(cv list(list(1.5 2.125) list(1.5 0.75)))
  tW(cv list(list(1.5 0.75) list(1.0 0.75)))
  tW(cv list(list(1.5 0.75) list(2.5 0.75)))
  tI(cv "gpdk090" "nmos1v" "M3" 2.5 0.75 "R0" list(list("w" "string" "7u") list("fw" "string" "7u") list("l" "string" "100n") list("fingers" "string" "1") list("m" "string" "1") list("ad" "string" "4.06p") list("as" "string" "4.06p") list("pd" "string" "15.16u") list("ps" "string" "15.16u")))
  tG(cv 2.75 0.5625)
  tW(cv list(list(2.75 0.75) list(3.0 0.75)))
  tG(cv 3.0 0.75)
  tI(cv "gpdk090" "pmos1v" "M3b" 2.5 2.5 "R0" list(list("w" "string" "28u") list("fw" "string" "28u") list("l" "string" "180n") list("fingers" "string" "1") list("m" "string" "1") list("ad" "string" "16.24p") list("as" "string" "16.24p") list("pd" "string" "57.16u") list("ps" "string" "57.16u")))
  tV(cv 2.75 2.6875)
  tW(cv list(list(2.75 2.5) list(3.0 2.5) list(3.0 2.875)))
  tV(cv 3.0 2.875)
  tL(cv "vbp" list(list(2.5 2.5) list(2.0 2.5)))
  tW(cv list(list(2.75 2.3125) list(2.75 1.625)))
  tW(cv list(list(2.75 1.625) list(2.75 0.9375)))
  tL(cv "out" list(list(2.75 1.625) list(3.75 1.625)))
  tW(cv list(list(3.75 1.625) list(3.75 1.25)))
  tW(cv list(list(3.75 1.625) list(4.5 1.625)))
  tI(cv "analogLib" "cap" "Cout" 3.75 1.25 "R0" list(list("c" "string" "30f")))
  tG(cv 3.75 0.875)
  tI(cv "gpdk090" "nmos1v" "Mf" -0.625 2.5 "R0" list(list("w" "string" "3.5u") list("fw" "string" "3.5u") list("l" "string" "100n") list("fingers" "string" "1") list("m" "string" "1") list("ad" "string" "2.03p") list("as" "string" "2.03p") list("pd" "string" "8.16u") list("ps" "string" "8.16u")))
  tV(cv -0.375 2.6875)
  tW(cv list(list(-0.375 2.5) list(-0.125 2.5)))
  tG(cv -0.125 2.5)
  tW(cv list(list(-0.375 2.3125) list(-0.375 1.75)))
  tW(cv list(list(-0.375 1.75) list(-0.375 1.25)))
  tL(cv "g" list(list(-0.625 2.5) list(-1.0 2.5)))
  tW(cv list(list(-1.0 2.5) list(-1.0 2.125)))
  tW(cv list(list(-1.0 2.5) list(-1.0 3.375)))
  tI(cv "analogLib" "cap" "Ca" -1.0 2.125 "R0" list(list("c" "string" "30f")))
  tW(cv list(list(-1.0 1.75) list(-0.375 1.75)))
  tI(cv "gpdk090" "pmos1v" "Mt" 2.0 3.625 "R270" list(list("w" "string" "12u") list("fw" "string" "12u") list("l" "string" "100n") list("fingers" "string" "1") list("m" "string" "1") list("ad" "string" "6.96p") list("as" "string" "6.96p") list("pd" "string" "25.16u") list("ps" "string" "25.16u")))
  tL(cv "vt" list(list(2.0 3.625) list(2.0 3.875)))
  tW(cv list(list(-1.0 3.375) list(1.8125 3.375)))
  tW(cv list(list(2.1875 3.375) list(2.375 3.375)))
  tW(cv list(list(2.375 3.375) list(4.5 3.375) list(4.5 1.625)))
  tW(cv list(list(2.0 3.375) list(2.0 3.125) list(2.375 3.125) list(2.375 3.375)))
  tL(cv "in" list(list(-0.375 1.25) list(0.75 1.25)))
  tW(cv list(list(-0.375 1.25) list(-1.0 1.25)))
  tI(cv "analogLib" "cap" "Cpd" -1.0 1.25 "R0" list(list("c" "string" "50f")))
  tG(cv -1.0 0.875)
  tW(cv list(list(-1.0 1.25) list(-1.75 1.25)))
  tI(cv "analogLib" "idc" "Iin" -1.75 0.875 "R180" list(list("idc" "string" "0") list("acm" "string" "1")))
  tG(cv -1.75 0.875)
  tI(cv "gpdk090" "pmos1v" "Mbp" -4.5 2.5 "R0" list(list("w" "string" "2u") list("fw" "string" "2u") list("l" "string" "180n") list("fingers" "string" "1") list("m" "string" "1") list("ad" "string" "1.16p") list("as" "string" "1.16p") list("pd" "string" "5.16u") list("ps" "string" "5.16u")))
  tW(cv list(list(-4.25 2.6875) list(-4.25 2.75)))
  tW(cv list(list(-4.25 2.75) list(-4.25 2.875)))
  tV(cv -4.25 2.875)
  tW(cv list(list(-4.25 2.5) list(-4.0 2.5) list(-4.0 2.75) list(-4.25 2.75)))
  tW(cv list(list(-4.25 2.3125) list(-4.25 2.125)))
  tW(cv list(list(-4.25 2.125) list(-4.25 2.0)))
  tW(cv list(list(-4.25 2.125) list(-4.75 2.125) list(-4.75 2.5) list(-4.5 2.5)))
  tL(cv "vbp" list(list(-4.25 2.0) list(-3.5 2.0)))
  tW(cv list(list(-3.5 2.0) list(-3.5 2.5) list(-3.0 2.5)))
  tW(cv list(list(-4.25 2.0) list(-4.25 1.625)))
  tI(cv "analogLib" "idc" "Iref" -4.25 1.625 "R0" list(list("idc" "string" "50u")))
  tG(cv -4.25 1.25)
  tI(cv "gpdk090" "pmos1v" "Mbr" -3.0 2.5 "R0" list(list("w" "string" "2u") list("fw" "string" "2u") list("l" "string" "180n") list("fingers" "string" "1") list("m" "string" "1") list("ad" "string" "1.16p") list("as" "string" "1.16p") list("pd" "string" "5.16u") list("ps" "string" "5.16u")))
  tW(cv list(list(-2.75 2.6875) list(-2.75 2.75)))
  tW(cv list(list(-2.75 2.75) list(-2.75 2.875)))
  tV(cv -2.75 2.875)
  tW(cv list(list(-2.75 2.5) list(-2.5 2.5) list(-2.5 2.75) list(-2.75 2.75)))
  tW(cv list(list(-2.75 2.3125) list(-2.75 2.125)))
  tW(cv list(list(-2.75 2.125) list(-2.75 2.0)))
  tW(cv list(list(-2.75 2.0) list(-2.75 1.875)))
  tI(cv "gpdk090" "nmos1v" "Mbn" -3.0 1.6875 "R0" list(list("w" "string" "0.4u") list("fw" "string" "0.4u") list("l" "string" "100n") list("fingers" "string" "1") list("m" "string" "1") list("ad" "string" "0.232p") list("as" "string" "0.232p") list("pd" "string" "1.96u") list("ps" "string" "1.96u")))
  tW(cv list(list(-2.75 1.6875) list(-2.5 1.6875)))
  tG(cv -2.5 1.6875)
  tW(cv list(list(-3.0 1.6875) list(-3.25 1.6875) list(-3.25 2.125) list(-2.75 2.125)))
  tL(cv "vb1" list(list(-2.75 2.0) list(-2.0 2.0)))
  tI(cv "analogLib" "cap" "Cb" -2.0 2.0 "R0" list(list("c" "string" "2p")))
  tG(cv -2.0 1.625)
  tL(cv "vr" list(list(-2.75 1.5) list(-2.75 1.25)))
  tI(cv "analogLib" "res" "Rb" -2.75 1.25 "R0" list(list("r" "string" "4.2k")))
  tG(cv -2.75 0.875)
  tI(cv "analogLib" "vdc" "Vdd" -5.5 1.625 "R0" list(list("vdc" "string" "1")))
  tW(cv list(list(-5.5 1.625) list(-5.5 1.875)))
  tV(cv -5.5 1.875)
  tG(cv -5.5 1.25)
  tI(cv "analogLib" "vdc" "Vtune" -6.25 1.625 "R0" list(list("vdc" "string" "vtn")))
  tL(cv "vt" list(list(-6.25 1.625) list(-6.25 2.0)))
  tG(cv -6.25 1.25)
  tNote(cv -6.25 4.3 "Proposed TIA v1: FVF input + current mirror + voltage-tuned gyrator-C feedback (Mf, Mt, Ca) - GPDK090, VDD = 1 V" 0.12)
  tNote(cv -6.25 4.1 "Sizes = paper Table I (v1). L = 100 nm where the paper used 90 nm (GPDK090 minimum); 180 nm devices unchanged." 0.08)
  tNote(cv -6.25 3.95 "Bias generator (left) drives the core through labelled nets vbp and vb1; Vtune drives net vt." 0.08)
  tNote(cv -5.0 3.0 "BIAS GENERATOR" 0.1)
  tNote(cv -1.25 3.55 "TUNABLE ACTIVE INDUCTOR (Mf, Mt, Ca)" 0.1)
  tNote(cv 0.0 0.2 "FVF INPUT STAGE + MIRROR" 0.1)
  schCheck(cv)
  printf("BUILT TIA_proposed_v1_gpdk090: errors/warnings %L\n" schCheck(cv))
  dbSave(cv)
  dbClose(cv)
  t))
tiaBuild_TIA_2020_base_gpdk090("TIA_Proj")
tiaBuild_TIA_proposed_v1_gpdk090("TIA_Proj")
