simulator lang=spectre
global 0
include "/home/buet/cadence/gpdk090_v4.6/models/spectre/gpdk090.scs" section=NN
simOpts options temp=35 tnom=27 reltol=1e-4 vabstol=1e-7 iabstol=1e-13 gmin=1e-15
parameters cl=3e-14 cpd=5e-14 csc=1 idc=0 rsc=1 vdd=1 vtn=0.180117
parameters p_ca=2.2717e-14 p_iref=4.89195e-05 p_rb=4345.19 p_rn=5443.9 p_w1=3.16859 p_w2=3.09895 p_w3=6.21607 p_w3b=27.2134 p_wbn=0.4 p_wf=3.425 p_wt=6.79703
Vdd (vdd 0) vsource dc=vdd
Iref (vbp 0) isource dc=p_iref
Mbp (vbp vbp vdd vdd) gpdk090_pmos1v w=2*1u l=180n ad=2*0.58*1p as=2*0.58*1p pd=2*(2+0.58)*1u ps=2*(2+0.58)*1u
Mbr (vb1 vbp vdd vdd) gpdk090_pmos1v w=2*1u l=180n ad=2*0.58*1p as=2*0.58*1p pd=2*(2+0.58)*1u ps=2*(2+0.58)*1u
Mbn (vb1 vb1 vr 0) gpdk090_nmos1v w=(p_wbn)*1u l=100n ad=(p_wbn)*0.58*1p as=(p_wbn)*0.58*1p pd=2*((p_wbn)+0.58)*1u ps=2*((p_wbn)+0.58)*1u
Rb (vr 0) resistor r=p_rb*rsc
Cb (vb1 0) capacitor c=2p
Rn (vdd n) resistor r=p_rn*rsc
M1 (n vb1 inp 0) gpdk090_nmos1v w=(p_w1)*1u l=100n ad=(p_w1)*0.58*1p as=(p_w1)*0.58*1p pd=2*((p_w1)+0.58)*1u ps=2*((p_w1)+0.58)*1u
IPl (n g2) iprobe
M2 (inp g2 0 0) gpdk090_nmos1v w=(p_w2)*1u l=100n ad=(p_w2)*0.58*1p as=(p_w2)*0.58*1p pd=2*((p_w2)+0.58)*1u ps=2*((p_w2)+0.58)*1u
M3 (outp n 0 0) gpdk090_nmos1v w=(p_w3)*1u l=100n ad=(p_w3)*0.58*1p as=(p_w3)*0.58*1p pd=2*((p_w3)+0.58)*1u ps=2*((p_w3)+0.58)*1u
M3b (outp vbp vdd vdd) gpdk090_pmos1v w=(p_w3b)*1u l=180n ad=(p_w3b)*0.58*1p as=(p_w3b)*0.58*1p pd=2*((p_w3b)+0.58)*1u ps=2*((p_w3b)+0.58)*1u
Vt (vt 0) vsource dc=vtn
Mf (vdd g fs 0) gpdk090_nmos1v w=(p_wf)*1u l=100n ad=(p_wf)*0.58*1p as=(p_wf)*0.58*1p pd=2*((p_wf)+0.58)*1u ps=2*((p_wf)+0.58)*1u
Mt (g vt outp outp) gpdk090_pmos1v w=(p_wt)*1u l=100n ad=(p_wt)*0.58*1p as=(p_wt)*0.58*1p pd=2*((p_wt)+0.58)*1u ps=2*((p_wt)+0.58)*1u
Ca (g inp) capacitor c=p_ca*csc
IPg (fs inp) iprobe
Mq (nq vbp vdd vdd) gpdk090_pmos1v w=0.891436*1u l=180n ad=0.891436*0.58*1p as=0.891436*0.58*1p pd=2*(0.891436+0.58)*1u ps=2*(0.891436+0.58)*1u
Mnq (nq nq 0 0) gpdk090_nmos1v w=2*1u l=1440n ad=2*0.58*1p as=2*0.58*1p pd=2*(2+0.58)*1u ps=2*(2+0.58)*1u
Rt1 (outp to) resistor r=100k
Ct1 (to 0) capacitor c=0.2p
Rt2 (inp ti) resistor r=100k
Ct2 (ti 0) capacitor c=0.2p
Mr (vdd to vrep 0) gpdk090_nmos1v w=(p_wf/2)*1u l=100n ad=(p_wf/2)*0.58*1p as=(p_wf/2)*0.58*1p pd=2*((p_wf/2)+0.58)*1u ps=2*((p_wf/2)+0.58)*1u
Mns (vrep nq 0 0) gpdk090_nmos1v w=5.7*1u l=1440n ad=5.7*0.58*1p as=5.7*0.58*1p pd=2*(5.7+0.58)*1u ps=2*(5.7+0.58)*1u
Mtp (tp vbp vdd vdd) gpdk090_pmos1v w=0.4*1u l=720n ad=0.4*0.58*1p as=0.4*0.58*1p pd=2*(0.4+0.58)*1u ps=2*(0.4+0.58)*1u
Ma (oa ti tp vdd) gpdk090_pmos1v w=4*1u l=720n ad=4*0.58*1p as=4*0.58*1p pd=2*(4+0.58)*1u ps=2*(4+0.58)*1u
Mb (vx vrep tp vdd) gpdk090_pmos1v w=4*1u l=720n ad=4*0.58*1p as=4*0.58*1p pd=2*(4+0.58)*1u ps=2*(4+0.58)*1u
Mna (oa oa 0 0) gpdk090_nmos1v w=1*1u l=1440n ad=1*0.58*1p as=1*0.58*1p pd=2*(1+0.58)*1u ps=2*(1+0.58)*1u
Mnb (vx oa 0 0) gpdk090_nmos1v w=1*1u l=1440n ad=1*0.58*1p as=1*0.58*1p pd=2*(1+0.58)*1u ps=2*(1+0.58)*1u
Cint (vx 0) capacitor c=2p
IPd (vx vxg) iprobe
Mdc (inp vxg 0 0) gpdk090_nmos1v w=6*1u l=180n ad=6*0.58*1p as=6*0.58*1p pd=2*(6+0.58)*1u ps=2*(6+0.58)*1u
Cpd (inp 0) capacitor c=cpd
Cl (outp 0) capacitor c=cl
Iin (0 inp) isource type=pwl file="/tmp/tia_work/prbsu_1.25e+10.pwl"
save outp inp
tr tran stop=2.192e-08 maxstep=2e-12
