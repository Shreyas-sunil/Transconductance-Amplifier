simulator lang=spectre
global 0
include "/home/buet/cadence/gpdk090_v4.6/models/spectre/gpdk090.scs" section=NN
simOpts options temp=35 tnom=27 reltol=1e-4 vabstol=1e-7 iabstol=1e-13 gmin=1e-15
parameters cl=3e-14 cpd=5e-14 csc=1 idc=0 rsc=1 vdd=1 vtn=0.17449028
parameters p_ca=1.9428364e-14 p_iref=5.1076559e-05 p_rb=4602.8862 p_rn=5862.0638 p_w1=3.1462514 p_w2=2.7452981 p_w3=5.6565461 p_w3b=28.412776 p_wbn=0.4 p_wf=3.7453199 p_wt=8.1899661
Vdd (vdd 0) vsource dc=vdd
Iref (vbp 0) isource dc=p_iref
Mbp (vbp vbp vdd vdd) gpdk090_pmos1v w=2*1u l=180n ad=2*0.58*1p as=2*0.58*1p pd=2*(2+0.58)*1u ps=2*(2+0.58)*1u
Mbr (vb1 vbp vdd vdd) gpdk090_pmos1v w=2*1u l=180n ad=2*0.58*1p as=2*0.58*1p pd=2*(2+0.58)*1u ps=2*(2+0.58)*1u
Mbn (vb1 vb1 vr 0) gpdk090_nmos1v w=(p_wbn)*1u l=100n ad=(p_wbn)*0.58*1p as=(p_wbn)*0.58*1p pd=2*((p_wbn)+0.58)*1u ps=2*((p_wbn)+0.58)*1u
Rb (vr 0) resistor r=p_rb*rsc
Cb (vb1 0) capacitor c=2p
Rn (vdd n) resistor r=p_rn*rsc
M1 (n vb1 inp 0) gpdk090_nmos1v w=(p_w1)*1u l=100n ad=(p_w1)*0.58*1p as=(p_w1)*0.58*1p pd=2*((p_w1)+0.58)*1u ps=2*((p_w1)+0.58)*1u
IPl (n g2) iprobe
M2 (inp g2 0 0) gpdk090_nmos1v w=(p_w2)*1u l=100n ad=(p_w2)*0.58*1p as=(p_w2)*0.58*1p pd=2*((p_w2)+0.58)*1u ps=2*((p_w2)+0.58)*1u
M3 (outp n 0 0) gpdk090_nmos1v w=(p_w3)*1u l=100n ad=(p_w3)*0.58*1p as=(p_w3)*0.58*1p pd=2*((p_w3)+0.58)*1u ps=2*((p_w3)+0.58)*1u
M3b (outp vbp vdd vdd) gpdk090_pmos1v w=(p_w3b)*1u l=180n ad=(p_w3b)*0.58*1p as=(p_w3b)*0.58*1p pd=2*((p_w3b)+0.58)*1u ps=2*((p_w3b)+0.58)*1u
Vt (vt 0) vsource dc=vtn
Mf (vdd g fs 0) gpdk090_nmos1v w=(p_wf)*1u l=100n ad=(p_wf)*0.58*1p as=(p_wf)*0.58*1p pd=2*((p_wf)+0.58)*1u ps=2*((p_wf)+0.58)*1u
Mt (g vt outp outp) gpdk090_pmos1v w=(p_wt)*1u l=100n ad=(p_wt)*0.58*1p as=(p_wt)*0.58*1p pd=2*((p_wt)+0.58)*1u ps=2*((p_wt)+0.58)*1u
Ca (g inp) capacitor c=p_ca*csc
IPg (fs inp) iprobe
Cpd (inp 0) capacitor c=cpd
Cl (outp 0) capacitor c=cl
Iin (0 inp) isource dc=idc mag=1
pset paramset {
p_ca p_iref p_rb p_rn p_w1 p_w2 p_w3 p_w3b p_wbn p_wf p_wt vtn
1.9428364e-14 5.1076559e-05 4602.8862 5862.0638 3.1462514 2.7452981 5.6565461 28.412776 0.4 3.7453199 8.1899661 0.17449028
2.7008364e-14 5.2184453e-05 4071.3849 6355.2811 3.3219793 3.3360694 7.5839869 31.96275 0.4 3.8144637 9.2263856 0.14477218
2.6028564e-14 5.6947107e-05 4471.5721 5357.8143 3.2181318 2.9149565 7.4582683 25.933941 0.4 2.5447957 9.3387734 0.18830368
2.3680694e-14 5.0979875e-05 5049.2767 5130.0556 3.1181897 3.2619326 5.9699764 27.556753 0.4 4.1339606 9.4521844 0.1867743
2.1931306e-14 6.0041452e-05 4621.1561 5590.9307 3.6084822 3.4811403 7.0938825 29.698315 0.4 3.5034032 8.6948849 0.20506449
2.375065e-14 4.6851216e-05 4661.8218 5599.0288 3.5303804 4.1765772 6.9803928 24.360511 0.4 3.0626734 9.6682448 0.18302672
2.3676736e-14 5.1993202e-05 4759.8383 5342.3602 3.5737125 3.2391608 6.2857718 25.642853 0.4 2.7148766 8.1103884 0.17122318
2.2984449e-14 4.538334e-05 3308.3454 5767.6008 3.1241023 3.435163 4.9654106 30.646107 0.4 2.8751521 9.691178 0.17002381
2.2710599e-14 5.1603207e-05 4305.4601 5180.5459 2.9140553 3.2561601 7.0949157 25.692454 0.4 3.2466239 9.2510875 0.15759331
2.4853719e-14 5.5019835e-05 3706.2881 5315.7047 3.2467935 3.0181497 5.7788831 24.555933 0.4 2.7880177 11.520212 0.18840042
2.7845041e-14 5.0196742e-05 4569.4777 4729.4301 2.8195115 3.3121869 7.1147229 26.929355 0.4 2.8133926 8.9082623 0.13973122
2.1641239e-14 4.4021986e-05 4171.7771 4991.1258 3.0773528 2.9965902 6.3581331 30.79539 0.4 3.0290399 11.229162 0.17654709
2.0421931e-14 5.1452104e-05 3826.4868 5103.5901 3.5221794 3.6328238 5.9048796 24.071704 0.4 3.0353069 9.3653527 0.19363343
2.2254323e-14 5.4518189e-05 4989.9251 4536.0689 3.6761694 2.731321 6.3400503 26.472047 0.4 2.7042935 10.304162 0.19849777
2.4242933e-14 4.7954924e-05 4443.8127 5501.8835 3.5291932 3.3960645 5.5715411 25.991825 0.4 3.1265643 7.0345775 0.20611046
2.8993989e-14 4.8401989e-05 3863.0846 4370.9484 3.3530391 3.0951523 5.9816571 24.881525 0.4 2.8801692 9.0286453 0.19638059
2.2368467e-14 5.3435505e-05 4206.8574 5245.3893 3.7646329 3.4577916 6.3534043 26.626045 0.4 2.865045 8.8247196 0.19930361
2.5320487e-14 5.1223181e-05 4111.5378 4574.5803 3.4449923 3.5981445 6.4405011 23.778725 0.4 3.028356 9.3027652 0.16306862
2.1801755e-14 5.1802331e-05 4184.261 4792.2023 3.6061834 3.3795831 5.7242015 24.590738 0.4 3.3571425 9.6337205 0.16850887
2.3089079e-14 5.8200304e-05 4149.4511 4694.1185 3.2846241 3.3759494 6.2414107 24.619362 0.4 2.7649059 8.947871 0.21213113
2.7089024e-14 4.5662035e-05 4840.1628 5288.8141 3.4272417 3.4466322 5.7182923 22.159267 0.4 3.1937648 8.2147153 0.17094831
2.47538e-14 4.1952345e-05 4207.1839 4804.0171 3.2685248 3.3214568 5.9041695 24.214341 0.4 3.1510001 7.7396394 0.16407886
2.4971743e-14 5.2499321e-05 4985.6713 5626.1836 3.4261436 3.2771817 5.4960352 30.986833 0.4 3.2446919 8.8718563 0.19834229
2.1348217e-14 5.7592627e-05 4480.0897 4639.0612 3.9890461 3.2618529 6.4556009 26.007659 0.4 2.9133931 10.070175 0.20425145
}
save outp inp n Vdd:p M1:ids M1:vgs M1:vds M1:vth M1:vdsat M1:gm M1:gds M1:gmbs M1:region M1:cgs M1:cgd M2:ids M2:vgs M2:vds M2:vth M2:vdsat M2:gm M2:gds M2:gmbs M2:region M2:cgs M2:cgd M3:ids M3:vgs M3:vds M3:vth M3:vdsat M3:gm M3:gds M3:gmbs M3:region M3:cgs M3:cgd M3b:ids M3b:vgs M3b:vds M3b:vth M3b:vdsat M3b:gm M3b:gds M3b:gmbs M3b:region M3b:cgs M3b:cgd Mf:ids Mf:vgs Mf:vds Mf:vth Mf:vdsat Mf:gm Mf:gds Mf:gmbs Mf:region Mf:cgs Mf:cgd Mt:ids Mt:vgs Mt:vds Mt:vth Mt:vdsat Mt:gm Mt:gds Mt:gmbs Mt:region Mt:cgs Mt:cgd Mbp:ids Mbp:vgs Mbp:vds Mbp:vth Mbp:vdsat Mbp:gm Mbp:gds Mbp:gmbs Mbp:region Mbp:cgs Mbp:cgd Mbr:ids Mbr:vgs Mbr:vds Mbr:vth Mbr:vdsat Mbr:gm Mbr:gds Mbr:gmbs Mbr:region Mbr:cgs Mbr:cgd Mbn:ids Mbn:vgs Mbn:vds Mbn:vth Mbn:vdsat Mbn:gm Mbn:gds Mbn:gmbs Mbn:region Mbn:cgs Mbn:cgd
swp sweep paramset=pset {
 dcop dc
 acx ac start=1e7 stop=1e11 dec=20
}
