simulator lang=spectre
global 0
include "/home/buet/cadence/gpdk090_v4.6/models/spectre/gpdk090.scs" section=NN
simOpts options temp=35 tnom=27 reltol=1e-4 vabstol=1e-7 iabstol=1e-13 gmin=1e-15
parameters cl=3e-14 cpd=5e-14 csc=1 idc=0 rsc=1 vdd=1 vtn=0.24
parameters p_lf=5.79219e-09 p_rsl=46.3498 p_vg2b=0.594684 p_vg3b=0.835283 p_w1=0.230911 p_w2=0.206088 p_w2b=4.43807 p_w3=3.23188 p_w3b=3.91694
Vdd (vdd 0) vsource dc=vdd
Vg3b (g3b 0) vsource dc=p_vg3b
Vg2b (g2b 0) vsource dc=p_vg2b
M2b (n g2b vdd vdd) gpdk090_pmos1v w=(p_w2b)*1u l=100n ad=(p_w2b)*0.58*1p as=(p_w2b)*0.58*1p pd=2*((p_w2b)+0.58)*1u ps=2*((p_w2b)+0.58)*1u
M1 (n vdd inp 0) gpdk090_nmos1v w=(p_w1)*1u l=100n ad=(p_w1)*0.58*1p as=(p_w1)*0.58*1p pd=2*((p_w1)+0.58)*1u ps=2*((p_w1)+0.58)*1u
IPl (n g2) iprobe
M2 (inp g2 0 0) gpdk090_nmos1v w=(p_w2)*1u l=100n ad=(p_w2)*0.58*1p as=(p_w2)*0.58*1p pd=2*((p_w2)+0.58)*1u ps=2*((p_w2)+0.58)*1u
M3 (outp n 0 0) gpdk090_nmos1v w=(p_w3)*1u l=100n ad=(p_w3)*0.58*1p as=(p_w3)*0.58*1p pd=2*((p_w3)+0.58)*1u ps=2*((p_w3)+0.58)*1u
M3b (outp g3b vdd vdd) gpdk090_pmos1v w=(p_w3b)*1u l=100n ad=(p_w3b)*0.58*1p as=(p_w3b)*0.58*1p pd=2*((p_w3b)+0.58)*1u ps=2*((p_w3b)+0.58)*1u
Lf (outp xl) inductor l=p_lf
Rsl (xl fs) resistor r=max(p_rsl,1e-3)
IPg (fs inp) iprobe
Cpd (inp 0) capacitor c=cpd
Cl (outp 0) capacitor c=cl
Iin (0 inp) isource dc=idc mag=1
save outp Vdd:p Mf:ids
mc1 montecarlo numruns=200 seed=4321 variations=mismatch donominal=no savefamilyplots=yes {
  dcm dc
  acm ac start=1e7 stop=1e11 dec=20
}
