simulator lang=spectre
global 0
include "/home/buet/cadence/gpdk090_v4.6/models/spectre/gpdk090.scs" section=NN
simOpts options temp=35 tnom=27 reltol=1e-4 vabstol=1e-7 iabstol=1e-13 gmin=1e-15
parameters cl=3e-14 cpd=5e-14 csc=1 idc=0 rsc=1 vdd=1 vtn=0.180117
parameters p_ca=2.2717e-14 p_iref=4.89195e-05 p_rb=4345.19 p_rn=5443.9 p_w1=3.16859 p_w2=3.09895 p_w3=6.21607 p_w3b=27.2134 p_wbn=0.4 p_wf=3.425 p_wt=6.79703
Vdd (vdd 0) vsource dc=vdd
Vt (vt 0) vsource dc=vtn
Vo (outp 0) vsource dc=0.603491
Mf (vdd g inp 0) gpdk090_nmos1v w=(p_wf)*1u l=100n ad=(p_wf)*0.58*1p as=(p_wf)*0.58*1p pd=2*((p_wf)+0.58)*1u ps=2*((p_wf)+0.58)*1u
Mt (g vt outp outp) gpdk090_pmos1v w=(p_wt)*1u l=100n ad=(p_wt)*0.58*1p as=(p_wt)*0.58*1p pd=2*((p_wt)+0.58)*1u ps=2*((p_wt)+0.58)*1u
Ca (g inp) capacitor c=p_ca
Lh (inp ih) inductor l=1
Vih (ih 0) vsource dc=0.264795
Itest (0 inp) isource dc=0 mag=1
save inp Mf:ids Mf:gm Mt:gds
swz sweep param=vtn values=[0 0.04 0.08 0.12 0.16 0.2 0.24 0.28 0.3 0.32 0.34 0.36 0.4] {
 dcz dc
 acz ac start=1e7 stop=1e11 dec=20
}
