simulator lang=spectre
global 0
include "/home/buet/cadence/gpdk090_v4.6/models/spectre/gpdk090.scs" section=NN
simOpts options temp=35 tnom=27 reltol=1e-4 vabstol=1e-7 iabstol=1e-13 gmin=1e-15
parameters cl=3e-14 cpd=5e-14 csc=1 idc=0 rsc=1 vdd=1 vtn=0.24
parameters p_lf=5.9912079e-09 p_rsl=46.163462 p_vg2b=0.58477591 p_vg3b=0.82031924 p_w1=0.23399247 p_w2=0.20258871 p_w2b=4.6011669 p_w3=3.3158443 p_w3b=3.9577334
Vdd (vdd 0) vsource dc=vdd
Vg3b (g3b 0) vsource dc=p_vg3b
Vg2b (g2b 0) vsource dc=p_vg2b
M2b (n g2b vdd vdd) gpdk090_pmos1v w=(p_w2b)*1u l=100n ad=(p_w2b)*0.58*1p as=(p_w2b)*0.58*1p pd=2*((p_w2b)+0.58)*1u ps=2*((p_w2b)+0.58)*1u
M1 (n vdd inp 0) gpdk090_nmos1v w=(p_w1)*1u l=100n ad=(p_w1)*0.58*1p as=(p_w1)*0.58*1p pd=2*((p_w1)+0.58)*1u ps=2*((p_w1)+0.58)*1u
IPl (n g2) iprobe
M2 (inp g2 0 0) gpdk090_nmos1v w=(p_w2)*1u l=100n ad=(p_w2)*0.58*1p as=(p_w2)*0.58*1p pd=2*((p_w2)+0.58)*1u ps=2*((p_w2)+0.58)*1u
M3 (outp n 0 0) gpdk090_nmos1v w=(p_w3)*1u l=100n ad=(p_w3)*0.58*1p as=(p_w3)*0.58*1p pd=2*((p_w3)+0.58)*1u ps=2*((p_w3)+0.58)*1u
M3b (outp g3b vdd vdd) gpdk090_pmos1v w=(p_w3b)*1u l=100n ad=(p_w3b)*0.58*1p as=(p_w3b)*0.58*1p pd=2*((p_w3b)+0.58)*1u ps=2*((p_w3b)+0.58)*1u
Lf (outp xl) inductor l=p_lf
Rsl (xl fs) resistor r=max(p_rsl,1e-3)
IPg (fs inp) iprobe
Cpd (inp 0) capacitor c=cpd
Cl (outp 0) capacitor c=cl
Iin (0 inp) isource dc=idc mag=1
pset paramset {
p_lf p_rsl p_vg2b p_vg3b p_w1 p_w2 p_w2b p_w3 p_w3b
5.9912079e-09 46.163462 0.58477591 0.82031924 0.23399247 0.20258871 4.6011669 3.3158443 3.9577334
5.6297485e-09 46.335349 0.58610875 0.80556169 0.2328826 0.21536474 4.3907561 3.2846076 4.018819
5.6819416e-09 46.145839 0.59788416 0.84320749 0.22568124 0.20698193 4.4285706 3.2939643 3.7937761
5.7272038e-09 46.047731 0.5909287 0.84743982 0.22802802 0.21768801 4.3757493 3.2866385 3.9976538
5.905037e-09 46.227324 0.58489841 0.83103189 0.23400607 0.20658796 4.4900233 3.2692342 3.8483004
5.684871e-09 47.214511 0.58893102 0.80922914 0.23966009 0.20268023 4.3559425 3.2950174 3.829274
5.6921825e-09 46.978622 0.58501244 0.87825251 0.23136267 0.21745464 4.4495602 3.2354584 3.8670197
5.7664708e-09 46.049229 0.59440455 0.84827541 0.22511457 0.20233888 4.2560782 3.330574 3.9111001
5.7906102e-09 46.314979 0.60675232 0.84066432 0.23487144 0.20539914 4.4273307 3.2282877 3.7737163
5.9198228e-09 45.403103 0.5829733 0.84656585 0.2311666 0.20946519 4.5921095 3.3545012 4.0267609
5.7661208e-09 47.579096 0.58431079 0.83384233 0.23555975 0.20520961 4.4273371 3.2091384 4.0253156
5.5133189e-09 47.113439 0.60742217 0.83407529 0.23351772 0.20213459 4.5376313 3.4358806 3.8455677
5.9562137e-09 46.31599 0.59067771 0.82718707 0.23003728 0.20099279 4.319178 3.341136 3.9155571
5.8565464e-09 46.535974 0.60038115 0.81018041 0.22657187 0.20871439 4.5275689 3.1587396 3.8719136
5.6697004e-09 46.741649 0.5987946 0.8358313 0.22792907 0.20750771 4.4409054 3.1841719 3.9431297
5.7157115e-09 46.920952 0.6021765 0.8238745 0.23363883 0.20636512 4.3758489 3.1733346 3.7888186
5.6626828e-09 46.557909 0.60922092 0.82485283 0.23164989 0.20751212 4.5079083 3.2606489 4.0142527
5.8816505e-09 45.89267 0.59942143 0.7970593 0.23008457 0.20617215 4.4897968 3.2124343 3.9826936
5.9472654e-09 45.846145 0.58825794 0.83964564 0.23318736 0.20668165 4.5124399 3.1563502 3.978191
5.9289106e-09 47.015804 0.59977877 0.83132385 0.23276479 0.20577952 4.2994484 3.1929872 3.9137624
5.7327468e-09 45.790217 0.59193327 0.82909807 0.23123137 0.20588768 4.453355 3.2967262 3.9276531
5.839462e-09 45.616361 0.56063741 0.82862088 0.2340608 0.20469418 4.3830897 3.1527289 3.987422
5.7313963e-09 46.497033 0.60828721 0.84428699 0.24150771 0.20554222 4.5237626 3.2770264 3.8659531
5.7977156e-09 46.010936 0.58262157 0.84030836 0.22736029 0.21312824 4.3728031 3.1968846 3.9241054
}
save outp inp n Vdd:p M1:ids M1:vgs M1:vds M1:vth M1:vdsat M1:gm M1:gds M1:gmbs M1:region M1:cgs M1:cgd M2:ids M2:vgs M2:vds M2:vth M2:vdsat M2:gm M2:gds M2:gmbs M2:region M2:cgs M2:cgd M3:ids M3:vgs M3:vds M3:vth M3:vdsat M3:gm M3:gds M3:gmbs M3:region M3:cgs M3:cgd M3b:ids M3b:vgs M3b:vds M3b:vth M3b:vdsat M3b:gm M3b:gds M3b:gmbs M3b:region M3b:cgs M3b:cgd M2b:ids M2b:vgs M2b:vds M2b:vth M2b:vdsat M2b:gm M2b:gds M2b:gmbs M2b:region M2b:cgs M2b:cgd
swp sweep paramset=pset {
 dcop dc
 acx ac start=1e7 stop=1e11 dec=20
}
