simulator lang=spectre
global 0
include "/home/buet/cadence/gpdk090_v4.6/models/spectre/gpdk090.scs" section=NN
simOpts options temp=35 tnom=27 reltol=1e-4 vabstol=1e-7 iabstol=1e-13 gmin=1e-15
parameters cl=3e-14 cpd=5e-14 csc=1 idc=0 rsc=1 vdd=1 vtn=0.180117
parameters p_ca=2.2717e-14 p_iref=4.89195e-05 p_rb=4345.19 p_rn=5443.9 p_w1=3.16859 p_w2=3.09895 p_w3=6.21607 p_w3b=27.2134 p_wbn=0.4 p_wf=3.425 p_wt=6.79703
Vdd (vdd 0) vsource dc=vdd
Iref (vbp 0) isource dc=p_iref
Mbp (vbp vbp vdd vdd) gpdk090_pmos1v w=2*1u l=180n ad=2*0.58*1p as=2*0.58*1p pd=2*(2+0.58)*1u ps=2*(2+0.58)*1u
Mbr (vb1 vbp vdd vdd) gpdk090_pmos1v w=2*1u l=180n ad=2*0.58*1p as=2*0.58*1p pd=2*(2+0.58)*1u ps=2*(2+0.58)*1u
Mbn (vb1 vb1 vr 0) gpdk090_nmos1v w=(p_wbn)*1u l=100n ad=(p_wbn)*0.58*1p as=(p_wbn)*0.58*1p pd=2*((p_wbn)+0.58)*1u ps=2*((p_wbn)+0.58)*1u
Rb (vr 0) resistor r=p_rb*rsc
Cb (vb1 0) capacitor c=2p
Rn (vdd n) resistor r=p_rn*rsc
M1 (n vb1 inp 0) gpdk090_nmos1v w=(p_w1)*1u l=100n ad=(p_w1)*0.58*1p as=(p_w1)*0.58*1p pd=2*((p_w1)+0.58)*1u ps=2*((p_w1)+0.58)*1u
IPl (n g2) iprobe
M2 (inp g2 0 0) gpdk090_nmos1v w=(p_w2)*1u l=100n ad=(p_w2)*0.58*1p as=(p_w2)*0.58*1p pd=2*((p_w2)+0.58)*1u ps=2*((p_w2)+0.58)*1u
M3 (outp n 0 0) gpdk090_nmos1v w=(p_w3)*1u l=100n ad=(p_w3)*0.58*1p as=(p_w3)*0.58*1p pd=2*((p_w3)+0.58)*1u ps=2*((p_w3)+0.58)*1u
M3b (outp vbp vdd vdd) gpdk090_pmos1v w=(p_w3b)*1u l=180n ad=(p_w3b)*0.58*1p as=(p_w3b)*0.58*1p pd=2*((p_w3b)+0.58)*1u ps=2*((p_w3b)+0.58)*1u
Vt (vt 0) vsource dc=vtn
Mf (vdd g fs 0) gpdk090_nmos1v w=(p_wf)*1u l=100n ad=(p_wf)*0.58*1p as=(p_wf)*0.58*1p pd=2*((p_wf)+0.58)*1u ps=2*((p_wf)+0.58)*1u
Mt (g vt outp outp) gpdk090_pmos1v w=(p_wt)*1u l=100n ad=(p_wt)*0.58*1p as=(p_wt)*0.58*1p pd=2*((p_wt)+0.58)*1u ps=2*((p_wt)+0.58)*1u
Ca (g inp) capacitor c=p_ca*csc
IPg (fs inp) iprobe
Mq (nq vbp vdd vdd) gpdk090_pmos1v w=0.891436*1u l=180n ad=0.891436*0.58*1p as=0.891436*0.58*1p pd=2*(0.891436+0.58)*1u ps=2*(0.891436+0.58)*1u
Mnq (nq nq 0 0) gpdk090_nmos1v w=2*1u l=1440n ad=2*0.58*1p as=2*0.58*1p pd=2*(2+0.58)*1u ps=2*(2+0.58)*1u
Rt1 (outp to) resistor r=100k
Ct1 (to 0) capacitor c=0.2p
Rt2 (inp ti) resistor r=100k
Ct2 (ti 0) capacitor c=0.2p
Mr (vdd to vrep 0) gpdk090_nmos1v w=(p_wf/2)*1u l=100n ad=(p_wf/2)*0.58*1p as=(p_wf/2)*0.58*1p pd=2*((p_wf/2)+0.58)*1u ps=2*((p_wf/2)+0.58)*1u
Mns (vrep nq 0 0) gpdk090_nmos1v w=5.7*1u l=1440n ad=5.7*0.58*1p as=5.7*0.58*1p pd=2*(5.7+0.58)*1u ps=2*(5.7+0.58)*1u
Mtp (tp vbp vdd vdd) gpdk090_pmos1v w=0.4*1u l=720n ad=0.4*0.58*1p as=0.4*0.58*1p pd=2*(0.4+0.58)*1u ps=2*(0.4+0.58)*1u
Ma (oa ti tp vdd) gpdk090_pmos1v w=4*1u l=720n ad=4*0.58*1p as=4*0.58*1p pd=2*(4+0.58)*1u ps=2*(4+0.58)*1u
Mb (vx vrep tp vdd) gpdk090_pmos1v w=4*1u l=720n ad=4*0.58*1p as=4*0.58*1p pd=2*(4+0.58)*1u ps=2*(4+0.58)*1u
Mna (oa oa 0 0) gpdk090_nmos1v w=1*1u l=1440n ad=1*0.58*1p as=1*0.58*1p pd=2*(1+0.58)*1u ps=2*(1+0.58)*1u
Mnb (vx oa 0 0) gpdk090_nmos1v w=1*1u l=1440n ad=1*0.58*1p as=1*0.58*1p pd=2*(1+0.58)*1u ps=2*(1+0.58)*1u
Cint (vx 0) capacitor c=2p
IPd (vx vxg) iprobe
Mdc (inp vxg 0 0) gpdk090_nmos1v w=6*1u l=180n ad=6*0.58*1p as=6*0.58*1p pd=2*(6+0.58)*1u ps=2*(6+0.58)*1u
Cpd (inp 0) capacitor c=cpd
Cl (outp 0) capacitor c=cl
Iin (0 inp) isource dc=idc mag=1
save outp inp n Vdd:p M1:ids M1:vgs M1:vds M1:vth M1:vdsat M1:gm M1:gds M1:gmbs M1:region M1:cgs M1:cgd M2:ids M2:vgs M2:vds M2:vth M2:vdsat M2:gm M2:gds M2:gmbs M2:region M2:cgs M2:cgd M3:ids M3:vgs M3:vds M3:vth M3:vdsat M3:gm M3:gds M3:gmbs M3:region M3:cgs M3:cgd M3b:ids M3b:vgs M3b:vds M3b:vth M3b:vdsat M3b:gm M3b:gds M3b:gmbs M3b:region M3b:cgs M3b:cgd Mf:ids Mf:vgs Mf:vds Mf:vth Mf:vdsat Mf:gm Mf:gds Mf:gmbs Mf:region Mf:cgs Mf:cgd Mt:ids Mt:vgs Mt:vds Mt:vth Mt:vdsat Mt:gm Mt:gds Mt:gmbs Mt:region Mt:cgs Mt:cgd Mbp:ids Mbp:vgs Mbp:vds Mbp:vth Mbp:vdsat Mbp:gm Mbp:gds Mbp:gmbs Mbp:region Mbp:cgs Mbp:cgd Mbr:ids Mbr:vgs Mbr:vds Mbr:vth Mbr:vdsat Mbr:gm Mbr:gds Mbr:gmbs Mbr:region Mbr:cgs Mbr:cgd Mbn:ids Mbn:vgs Mbn:vds Mbn:vth Mbn:vdsat Mbn:gm Mbn:gds Mbn:gmbs Mbn:region Mbn:cgs Mbn:cgd Mq:ids Mq:vgs Mq:vds Mq:vth Mq:vdsat Mq:gm Mq:gds Mq:gmbs Mq:region Mq:cgs Mq:cgd Mnq:ids Mnq:vgs Mnq:vds Mnq:vth Mnq:vdsat Mnq:gm Mnq:gds Mnq:gmbs Mnq:region Mnq:cgs Mnq:cgd Mr:ids Mr:vgs Mr:vds Mr:vth Mr:vdsat Mr:gm Mr:gds Mr:gmbs Mr:region Mr:cgs Mr:cgd Mns:ids Mns:vgs Mns:vds Mns:vth Mns:vdsat Mns:gm Mns:gds Mns:gmbs Mns:region Mns:cgs Mns:cgd Mtp:ids Mtp:vgs Mtp:vds Mtp:vth Mtp:vdsat Mtp:gm Mtp:gds Mtp:gmbs Mtp:region Mtp:cgs Mtp:cgd Ma:ids Ma:vgs Ma:vds Ma:vth Ma:vdsat Ma:gm Ma:gds Ma:gmbs Ma:region Ma:cgs Ma:cgd Mb:ids Mb:vgs Mb:vds Mb:vth Mb:vdsat Mb:gm Mb:gds Mb:gmbs Mb:region Mb:cgs Mb:cgd Mna:ids Mna:vgs Mna:vds Mna:vth Mna:vdsat Mna:gm Mna:gds Mna:gmbs Mna:region Mna:cgs Mna:cgd Mnb:ids Mnb:vgs Mnb:vds Mnb:vth Mnb:vdsat Mnb:gm Mnb:gds Mnb:gmbs Mnb:region Mnb:cgs Mnb:cgd Mdc:ids Mdc:vgs Mdc:vds Mdc:vth Mdc:vdsat Mdc:gm Mdc:gds Mdc:gmbs Mdc:region Mdc:cgs Mdc:cgd
swi sweep param=idc values=[0 5e-06 1e-05 2.5e-05 5e-05 7.5e-05 0.0001 0.00015 0.0002 0.0003 0.0004 0.0005] {
 dcop dc
 acx ac start=1e3 stop=1e11 dec=20
 lgd stb start=1e2 stop=1e10 dec=20 probe=IPd
 nz (outp 0) noise start=1e9 stop=1e10 dec=5 iprobe=Iin
}
