;; Creates the second-pass GPDK090 cells by copying the verified first-pass schematics
;; and changing parameters only (no rewiring).  Run in the CIW after build_gpdk090.il and
;; build_regain.il:   load("build_pass2.il")
;; NOTE: generated from gpdk090_spectre/csv/design_*.csv; not yet executed in Virtuoso.
;; The Spectre netlists in gpdk090_spectre/netlists are the simulated reference.
procedure(tiaCopy(lib from to)
  let((src dst)
    src = dbOpenCellViewByType(lib from "schematic" "schematic" "r")
    dst = dbCopyCellView(src lib to "schematic" nil nil t)
    dbClose(src)
    dbOpenCellViewByType(lib to "schematic" "schematic" "a")))
procedure(tiaInst(cv name)
  car(setof(i cv~>instances i~>name == name)))
procedure(tiaSetMos(cv name w ad pd)
  let((i) i = tiaInst(cv name)
    unless(i error("no instance %s" name))
    dbReplaceProp(i "w" "string" sprintf(nil "%gu" w))
    dbReplaceProp(i "fw" "string" sprintf(nil "%gu" w))
    dbReplaceProp(i "ad" "string" sprintf(nil "%gp" ad))
    dbReplaceProp(i "as" "string" sprintf(nil "%gp" ad))
    dbReplaceProp(i "pd" "string" sprintf(nil "%gu" pd))
    dbReplaceProp(i "ps" "string" sprintf(nil "%gu" pd))))
procedure(tiaSet(cv name prop val)
  let((i) i = tiaInst(cv name)
    unless(i error("no instance %s" name))
    dbReplaceProp(i prop "string" val)))
procedure(tiaBuildV2(lib)
 let((cv)
  cv = tiaCopy(lib "TIA_proposed_v1_gpdk090" "TIA_proposed_v2_gpdk090")
  tiaSetMos(cv "M1" 3.169 1.838 7.497)
  tiaSetMos(cv "M2" 3.099 1.797 7.358)
  tiaSetMos(cv "M3" 6.216 3.605 13.59)
  tiaSetMos(cv "M3b" 27.21 15.78 55.59)
  tiaSetMos(cv "Mf" 3.425 1.986 8.01)
  tiaSetMos(cv "Mt" 6.797 3.942 14.75)
  tiaSet(cv "Ca" "c" "22.72f")
  tiaSet(cv "Rn" "r" "5443.9")
  tiaSet(cv "Rb" "r" "4345.2")
  tiaSet(cv "Iref" "idc" "48.92u")
  ;; set the design variable vtn to 0.180 V in ADE for the nominal point
  schCheck(cv) dbSave(cv) dbClose(cv) t))
procedure(tiaBuildB1(lib)
 let((cv)
  cv = tiaCopy(lib "TIA_2020_regain_gpdk090" "TIA_2020_B1_gpdk090")
  tiaSetMos(cv "M1" 0.2309 0.1339 1.622)
  tiaSetMos(cv "M2" 0.2061 0.1195 1.572)
  tiaSetMos(cv "M3" 3.232 1.874 7.624)
  tiaSetMos(cv "M3b" 3.917 2.272 8.994)
  tiaSetMos(cv "M2b" 4.438 2.574 10.04)
  tiaSet(cv "Vg2b" "vdc" "0.5947")
  tiaSet(cv "Vg3b" "vdc" "0.8353")
  tiaSet(cv "Lf" "l" "5.792n")
  tiaSet(cv "Rsl" "r" "46.35")
  schCheck(cv) dbSave(cv) dbClose(cv) t))
tiaBuildV2("TIA_Proj")
tiaBuildB1("TIA_Proj")
