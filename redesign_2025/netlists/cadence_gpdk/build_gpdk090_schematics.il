;; Draws every TIA of the 2025 redesign study as a Virtuoso schematic with gpdk090 devices.
;; CIW:  load("build_gpdk090_schematics.il")  tia25BuildAll("TIA25")   (library TIA25 must exist,
;; attached to gpdk090).  NMOS/PMOS = gpdk090 nmos1v/pmos1v, passives and sources = analogLib.
;; Nets are joined by wire labels (same name = same net).  Generated outside Cadence: if a pin
;; name differs in your kit version (D G S B), edit tia25Place.
procedure( tia25Place(cv lib cell name x y props nets)
  let( (master inst term fig c pt pt2 w)
    master = dbOpenCellViewByType(lib cell "symbol")
    unless(master error("no master %s %s" lib cell))
    inst = dbCreateParamInst(cv master name list(x y) "R0" 1 props)
    foreach(n nets
      term = dbFindTermByName(master car(n))
      fig = car(term~>pins)~>fig
      c = centerBox(fig~>bBox)
      pt = dbTransformPoint(c inst~>transform)
      pt2 = list(xCoord(pt)+caddr(n) yCoord(pt)+cadddr(n))
      w = schCreateWire(cv "draw" "full" list(pt pt2) 0.0625 0.0625 0.0)
      schCreateWireLabel(cv car(w) pt2 cadr(n) "lowerLeft" "R0" "stick" 0.0625 nil))
    inst))

;; Abdollahi 2025 modified dual-feedback RGC with negative-RC network, re-sized for 1 V / PTM90 against 7 PVT conditions
procedure( tia25_base_mdfrgc_robust(lib)
  let( (cv)
    cv = dbOpenCellViewByType(lib "base_mdfrgc_robust" "schematic" "schematic" "w")
    tia25Place(cv "analogLib" "vdc" "Vdd" 0 0 list(list("vdc" "string" "1")) list(list("PLUS" "vdd" 0 0.25) list("MINUS" "gnd!" 0 -0.25)))
    tia25Place(cv "analogLib" "cap" "Cpd" 3.5 0 list(list("c" "string" "450f")) list(list("PLUS" "in" 0 0.25) list("MINUS" "gnd!" 0 -0.25)))
    tia25Place(cv "analogLib" "cap" "CL" 7 0 list(list("c" "string" "50f")) list(list("PLUS" "out" 0 0.25) list("MINUS" "gnd!" 0 -0.25)))
    tia25Place(cv "analogLib" "idc" "Iin" 10.5 0 list(list("idc" "string" "0") list("acm" "string" "1")) list(list("PLUS" "gnd!" 0 0.25) list("MINUS" "in" 0 -0.25)))
    tia25Place(cv "analogLib" "idc" "Ibn" 14 0 list(list("idc" "string" "20u")) list(list("PLUS" "vdd" 0 0.25) list("MINUS" "vbn" 0 -0.25)))
    tia25Place(cv "gpdk090" "nmos1v" "Mdn" 17.5 0 list(list("w" "string" "1u") list("fw" "string" "1u") list("l" "string" "200n") list("fingers" "string" "1") list("m" "string" "1")) list(list("D" "vbn" 0 0.25) list("G" "vbn" -0.25 0) list("S" "gnd!" 0 -0.25) list("B" "gnd!" 0.25 0)))
    tia25Place(cv "analogLib" "cap" "Cbn" 0 -3.25 list(list("c" "string" "2p")) list(list("PLUS" "vbn" 0 0.25) list("MINUS" "gnd!" 0 -0.25)))
    tia25Place(cv "gpdk090" "nmos1v" "Mb" 3.5 -3.25 list(list("w" "string" "23.76u") list("fw" "string" "23.76u") list("l" "string" "200n") list("fingers" "string" "1") list("m" "string" "1")) list(list("D" "in" 0 0.25) list("G" "vbn" -0.25 0) list("S" "gnd!" 0 -0.25) list("B" "gnd!" 0.25 0)))
    tia25Place(cv "gpdk090" "nmos1v" "M1" 7 -3.25 list(list("w" "string" "20.14u") list("fw" "string" "20.14u") list("l" "string" "100n") list("fingers" "string" "1") list("m" "string" "1")) list(list("D" "out" 0 0.25) list("G" "x" -0.25 0) list("S" "in" 0 -0.25) list("B" "gnd!" 0.25 0)))
    tia25Place(cv "analogLib" "res" "R1" 10.5 -3.25 list(list("r" "string" "692.88")) list(list("PLUS" "vdd" 0 0.25) list("MINUS" "out" 0 -0.25)))
    tia25Place(cv "gpdk090" "nmos1v" "M2" 14 -3.25 list(list("w" "string" "23.23u") list("fw" "string" "23.23u") list("l" "string" "100n") list("fingers" "string" "1") list("m" "string" "1")) list(list("D" "x" 0 0.25) list("G" "in" -0.25 0) list("S" "gnd!" 0 -0.25) list("B" "gnd!" 0.25 0)))
    tia25Place(cv "analogLib" "res" "R2" 17.5 -3.25 list(list("r" "string" "635.92")) list(list("PLUS" "vdd" 0 0.25) list("MINUS" "x" 0 -0.25)))
    tia25Place(cv "gpdk090" "nmos1v" "M3" 0 -6.5 list(list("w" "string" "3.273u") list("fw" "string" "3.273u") list("l" "string" "100n") list("fingers" "string" "1") list("m" "string" "1")) list(list("D" "x" 0 0.25) list("G" "out" -0.25 0) list("S" "s3" 0 -0.25) list("B" "gnd!" 0.25 0)))
    tia25Place(cv "analogLib" "res" "R3" 3.5 -6.5 list(list("r" "string" "5.9811k")) list(list("PLUS" "s3" 0 0.25) list("MINUS" "gnd!" 0 -0.25)))
    tia25Place(cv "analogLib" "cap" "C3" 7 -6.5 list(list("c" "string" "31.248f")) list(list("PLUS" "s3" 0 0.25) list("MINUS" "gnd!" 0 -0.25)))
    schCheck(cv) dbSave(cv) dbClose(cv) t))

;; Abdollahi 2025 MDFRGC re-sized for the nominal corner only (higher gain, corner-sensitive)
procedure( tia25_base_mdfrgc_nominal(lib)
  let( (cv)
    cv = dbOpenCellViewByType(lib "base_mdfrgc_nominal" "schematic" "schematic" "w")
    tia25Place(cv "analogLib" "vdc" "Vdd" 0 0 list(list("vdc" "string" "1")) list(list("PLUS" "vdd" 0 0.25) list("MINUS" "gnd!" 0 -0.25)))
    tia25Place(cv "analogLib" "cap" "Cpd" 3.5 0 list(list("c" "string" "450f")) list(list("PLUS" "in" 0 0.25) list("MINUS" "gnd!" 0 -0.25)))
    tia25Place(cv "analogLib" "cap" "CL" 7 0 list(list("c" "string" "50f")) list(list("PLUS" "out" 0 0.25) list("MINUS" "gnd!" 0 -0.25)))
    tia25Place(cv "analogLib" "idc" "Iin" 10.5 0 list(list("idc" "string" "0") list("acm" "string" "1")) list(list("PLUS" "gnd!" 0 0.25) list("MINUS" "in" 0 -0.25)))
    tia25Place(cv "analogLib" "idc" "Ibn" 14 0 list(list("idc" "string" "20u")) list(list("PLUS" "vdd" 0 0.25) list("MINUS" "vbn" 0 -0.25)))
    tia25Place(cv "gpdk090" "nmos1v" "Mdn" 17.5 0 list(list("w" "string" "1u") list("fw" "string" "1u") list("l" "string" "200n") list("fingers" "string" "1") list("m" "string" "1")) list(list("D" "vbn" 0 0.25) list("G" "vbn" -0.25 0) list("S" "gnd!" 0 -0.25) list("B" "gnd!" 0.25 0)))
    tia25Place(cv "analogLib" "cap" "Cbn" 0 -3.25 list(list("c" "string" "2p")) list(list("PLUS" "vbn" 0 0.25) list("MINUS" "gnd!" 0 -0.25)))
    tia25Place(cv "gpdk090" "nmos1v" "Mb" 3.5 -3.25 list(list("w" "string" "7.995u") list("fw" "string" "7.995u") list("l" "string" "200n") list("fingers" "string" "1") list("m" "string" "1")) list(list("D" "in" 0 0.25) list("G" "vbn" -0.25 0) list("S" "gnd!" 0 -0.25) list("B" "gnd!" 0.25 0)))
    tia25Place(cv "gpdk090" "nmos1v" "M1" 7 -3.25 list(list("w" "string" "6.663u") list("fw" "string" "6.663u") list("l" "string" "100n") list("fingers" "string" "1") list("m" "string" "1")) list(list("D" "out" 0 0.25) list("G" "x" -0.25 0) list("S" "in" 0 -0.25) list("B" "gnd!" 0.25 0)))
    tia25Place(cv "analogLib" "res" "R1" 10.5 -3.25 list(list("r" "string" "2.4582k")) list(list("PLUS" "vdd" 0 0.25) list("MINUS" "out" 0 -0.25)))
    tia25Place(cv "gpdk090" "nmos1v" "M2" 14 -3.25 list(list("w" "string" "30.35u") list("fw" "string" "30.35u") list("l" "string" "100n") list("fingers" "string" "1") list("m" "string" "1")) list(list("D" "x" 0 0.25) list("G" "in" -0.25 0) list("S" "gnd!" 0 -0.25) list("B" "gnd!" 0.25 0)))
    tia25Place(cv "analogLib" "res" "R2" 17.5 -3.25 list(list("r" "string" "830.97")) list(list("PLUS" "vdd" 0 0.25) list("MINUS" "x" 0 -0.25)))
    tia25Place(cv "gpdk090" "nmos1v" "M3" 0 -6.5 list(list("w" "string" "4.743u") list("fw" "string" "4.743u") list("l" "string" "100n") list("fingers" "string" "1") list("m" "string" "1")) list(list("D" "x" 0 0.25) list("G" "out" -0.25 0) list("S" "s3" 0 -0.25) list("B" "gnd!" 0.25 0)))
    tia25Place(cv "analogLib" "res" "R3" 3.5 -6.5 list(list("r" "string" "2.3197k")) list(list("PLUS" "s3" 0 0.25) list("MINUS" "gnd!" 0 -0.25)))
    tia25Place(cv "analogLib" "cap" "C3" 7 -6.5 list(list("c" "string" "90.269f")) list(list("PLUS" "s3" 0 0.25) list("MINUS" "gnd!" 0 -0.25)))
    schCheck(cv) dbSave(cv) dbClose(cv) t))

;; Conventional regulated-cascode TIA (Park-Yoo style), worst-case sized
procedure( tia25_ref_rgc_robust(lib)
  let( (cv)
    cv = dbOpenCellViewByType(lib "ref_rgc_robust" "schematic" "schematic" "w")
    tia25Place(cv "analogLib" "vdc" "Vdd" 0 0 list(list("vdc" "string" "1")) list(list("PLUS" "vdd" 0 0.25) list("MINUS" "gnd!" 0 -0.25)))
    tia25Place(cv "analogLib" "cap" "Cpd" 3.5 0 list(list("c" "string" "450f")) list(list("PLUS" "in" 0 0.25) list("MINUS" "gnd!" 0 -0.25)))
    tia25Place(cv "analogLib" "cap" "CL" 7 0 list(list("c" "string" "50f")) list(list("PLUS" "out" 0 0.25) list("MINUS" "gnd!" 0 -0.25)))
    tia25Place(cv "analogLib" "idc" "Iin" 10.5 0 list(list("idc" "string" "0") list("acm" "string" "1")) list(list("PLUS" "gnd!" 0 0.25) list("MINUS" "in" 0 -0.25)))
    tia25Place(cv "analogLib" "idc" "Ibn" 14 0 list(list("idc" "string" "20u")) list(list("PLUS" "vdd" 0 0.25) list("MINUS" "vbn" 0 -0.25)))
    tia25Place(cv "gpdk090" "nmos1v" "Mdn" 17.5 0 list(list("w" "string" "1u") list("fw" "string" "1u") list("l" "string" "200n") list("fingers" "string" "1") list("m" "string" "1")) list(list("D" "vbn" 0 0.25) list("G" "vbn" -0.25 0) list("S" "gnd!" 0 -0.25) list("B" "gnd!" 0.25 0)))
    tia25Place(cv "analogLib" "cap" "Cbn" 0 -3.25 list(list("c" "string" "2p")) list(list("PLUS" "vbn" 0 0.25) list("MINUS" "gnd!" 0 -0.25)))
    tia25Place(cv "gpdk090" "nmos1v" "Mb" 3.5 -3.25 list(list("w" "string" "23.9u") list("fw" "string" "23.9u") list("l" "string" "200n") list("fingers" "string" "1") list("m" "string" "1")) list(list("D" "in" 0 0.25) list("G" "vbn" -0.25 0) list("S" "gnd!" 0 -0.25) list("B" "gnd!" 0.25 0)))
    tia25Place(cv "gpdk090" "nmos1v" "M1" 7 -3.25 list(list("w" "string" "20.83u") list("fw" "string" "20.83u") list("l" "string" "100n") list("fingers" "string" "1") list("m" "string" "1")) list(list("D" "out" 0 0.25) list("G" "x" -0.25 0) list("S" "in" 0 -0.25) list("B" "gnd!" 0.25 0)))
    tia25Place(cv "analogLib" "res" "R1" 10.5 -3.25 list(list("r" "string" "635.71")) list(list("PLUS" "vdd" 0 0.25) list("MINUS" "out" 0 -0.25)))
    tia25Place(cv "gpdk090" "nmos1v" "M2" 14 -3.25 list(list("w" "string" "40u") list("fw" "string" "40u") list("l" "string" "100n") list("fingers" "string" "1") list("m" "string" "1")) list(list("D" "x" 0 0.25) list("G" "in" -0.25 0) list("S" "gnd!" 0 -0.25) list("B" "gnd!" 0.25 0)))
    tia25Place(cv "analogLib" "res" "R2" 17.5 -3.25 list(list("r" "string" "811.42")) list(list("PLUS" "vdd" 0 0.25) list("MINUS" "x" 0 -0.25)))
    schCheck(cv) dbSave(cv) dbClose(cv) t))

;; Base-paper MDFRGC with the A2 degeneration resistor shunted by a triode NMOS (control voltage vc)
procedure( tia25_prop_mdfrgc_trim(lib)
  let( (cv)
    cv = dbOpenCellViewByType(lib "prop_mdfrgc_trim" "schematic" "schematic" "w")
    tia25Place(cv "analogLib" "vdc" "Vdd" 0 0 list(list("vdc" "string" "1")) list(list("PLUS" "vdd" 0 0.25) list("MINUS" "gnd!" 0 -0.25)))
    tia25Place(cv "analogLib" "cap" "Cpd" 3.5 0 list(list("c" "string" "450f")) list(list("PLUS" "in" 0 0.25) list("MINUS" "gnd!" 0 -0.25)))
    tia25Place(cv "analogLib" "cap" "CL" 7 0 list(list("c" "string" "50f")) list(list("PLUS" "out" 0 0.25) list("MINUS" "gnd!" 0 -0.25)))
    tia25Place(cv "analogLib" "idc" "Iin" 10.5 0 list(list("idc" "string" "0") list("acm" "string" "1")) list(list("PLUS" "gnd!" 0 0.25) list("MINUS" "in" 0 -0.25)))
    tia25Place(cv "analogLib" "idc" "Ibn" 14 0 list(list("idc" "string" "20u")) list(list("PLUS" "vdd" 0 0.25) list("MINUS" "vbn" 0 -0.25)))
    tia25Place(cv "gpdk090" "nmos1v" "Mdn" 17.5 0 list(list("w" "string" "1u") list("fw" "string" "1u") list("l" "string" "200n") list("fingers" "string" "1") list("m" "string" "1")) list(list("D" "vbn" 0 0.25) list("G" "vbn" -0.25 0) list("S" "gnd!" 0 -0.25) list("B" "gnd!" 0.25 0)))
    tia25Place(cv "analogLib" "cap" "Cbn" 0 -3.25 list(list("c" "string" "2p")) list(list("PLUS" "vbn" 0 0.25) list("MINUS" "gnd!" 0 -0.25)))
    tia25Place(cv "gpdk090" "nmos1v" "Mb" 3.5 -3.25 list(list("w" "string" "9.662u") list("fw" "string" "9.662u") list("l" "string" "200n") list("fingers" "string" "1") list("m" "string" "1")) list(list("D" "in" 0 0.25) list("G" "vbn" -0.25 0) list("S" "gnd!" 0 -0.25) list("B" "gnd!" 0.25 0)))
    tia25Place(cv "gpdk090" "nmos1v" "M1" 7 -3.25 list(list("w" "string" "6.669u") list("fw" "string" "6.669u") list("l" "string" "100n") list("fingers" "string" "1") list("m" "string" "1")) list(list("D" "out" 0 0.25) list("G" "x" -0.25 0) list("S" "in" 0 -0.25) list("B" "gnd!" 0.25 0)))
    tia25Place(cv "analogLib" "res" "R1" 10.5 -3.25 list(list("r" "string" "2.4022k")) list(list("PLUS" "vdd" 0 0.25) list("MINUS" "out" 0 -0.25)))
    tia25Place(cv "gpdk090" "nmos1v" "M2" 14 -3.25 list(list("w" "string" "15.01u") list("fw" "string" "15.01u") list("l" "string" "100n") list("fingers" "string" "1") list("m" "string" "1")) list(list("D" "x" 0 0.25) list("G" "in" -0.25 0) list("S" "gnd!" 0 -0.25) list("B" "gnd!" 0.25 0)))
    tia25Place(cv "analogLib" "res" "R2" 17.5 -3.25 list(list("r" "string" "578.84")) list(list("PLUS" "vdd" 0 0.25) list("MINUS" "x" 0 -0.25)))
    tia25Place(cv "gpdk090" "nmos1v" "M3" 0 -6.5 list(list("w" "string" "9.747u") list("fw" "string" "9.747u") list("l" "string" "100n") list("fingers" "string" "1") list("m" "string" "1")) list(list("D" "x" 0 0.25) list("G" "out" -0.25 0) list("S" "s3" 0 -0.25) list("B" "gnd!" 0.25 0)))
    tia25Place(cv "analogLib" "res" "R3" 3.5 -6.5 list(list("r" "string" "1.1335k")) list(list("PLUS" "s3" 0 0.25) list("MINUS" "gnd!" 0 -0.25)))
    tia25Place(cv "analogLib" "cap" "C3" 7 -6.5 list(list("c" "string" "92.429f")) list(list("PLUS" "s3" 0 0.25) list("MINUS" "gnd!" 0 -0.25)))
    tia25Place(cv "gpdk090" "nmos1v" "Mr3" 10.5 -6.5 list(list("w" "string" "1.068u") list("fw" "string" "1.068u") list("l" "string" "100n") list("fingers" "string" "1") list("m" "string" "1")) list(list("D" "s3" 0 0.25) list("G" "vc" -0.25 0) list("S" "gnd!" 0 -0.25) list("B" "gnd!" 0.25 0)))
    tia25Place(cv "analogLib" "vdc" "Vc" 14 -6.5 list(list("vdc" "string" "302.91m")) list(list("PLUS" "vc" 0 0.25) list("MINUS" "gnd!" 0 -0.25)))
    schCheck(cv) dbSave(cv) dbClose(cv) t))

;; RGC with PMOS current-mirror output and a negative-RC path from the mirror node
procedure( tia25_var_cmnrc_robust(lib)
  let( (cv)
    cv = dbOpenCellViewByType(lib "var_cmnrc_robust" "schematic" "schematic" "w")
    tia25Place(cv "analogLib" "vdc" "Vdd" 0 0 list(list("vdc" "string" "1")) list(list("PLUS" "vdd" 0 0.25) list("MINUS" "gnd!" 0 -0.25)))
    tia25Place(cv "analogLib" "cap" "Cpd" 3.5 0 list(list("c" "string" "450f")) list(list("PLUS" "in" 0 0.25) list("MINUS" "gnd!" 0 -0.25)))
    tia25Place(cv "analogLib" "cap" "CL" 7 0 list(list("c" "string" "50f")) list(list("PLUS" "out" 0 0.25) list("MINUS" "gnd!" 0 -0.25)))
    tia25Place(cv "analogLib" "idc" "Iin" 10.5 0 list(list("idc" "string" "0") list("acm" "string" "1")) list(list("PLUS" "gnd!" 0 0.25) list("MINUS" "in" 0 -0.25)))
    tia25Place(cv "analogLib" "idc" "Ibn" 14 0 list(list("idc" "string" "20u")) list(list("PLUS" "vdd" 0 0.25) list("MINUS" "vbn" 0 -0.25)))
    tia25Place(cv "gpdk090" "nmos1v" "Mdn" 17.5 0 list(list("w" "string" "1u") list("fw" "string" "1u") list("l" "string" "200n") list("fingers" "string" "1") list("m" "string" "1")) list(list("D" "vbn" 0 0.25) list("G" "vbn" -0.25 0) list("S" "gnd!" 0 -0.25) list("B" "gnd!" 0.25 0)))
    tia25Place(cv "analogLib" "cap" "Cbn" 0 -3.25 list(list("c" "string" "2p")) list(list("PLUS" "vbn" 0 0.25) list("MINUS" "gnd!" 0 -0.25)))
    tia25Place(cv "gpdk090" "nmos1v" "Mb" 3.5 -3.25 list(list("w" "string" "15.83u") list("fw" "string" "15.83u") list("l" "string" "200n") list("fingers" "string" "1") list("m" "string" "1")) list(list("D" "in" 0 0.25) list("G" "vbn" -0.25 0) list("S" "gnd!" 0 -0.25) list("B" "gnd!" 0.25 0)))
    tia25Place(cv "gpdk090" "nmos1v" "M1" 7 -3.25 list(list("w" "string" "17.7u") list("fw" "string" "17.7u") list("l" "string" "100n") list("fingers" "string" "1") list("m" "string" "1")) list(list("D" "d1" 0 0.25) list("G" "x" -0.25 0) list("S" "in" 0 -0.25) list("B" "gnd!" 0.25 0)))
    tia25Place(cv "gpdk090" "nmos1v" "M2" 10.5 -3.25 list(list("w" "string" "36.29u") list("fw" "string" "36.29u") list("l" "string" "100n") list("fingers" "string" "1") list("m" "string" "1")) list(list("D" "x" 0 0.25) list("G" "in" -0.25 0) list("S" "gnd!" 0 -0.25) list("B" "gnd!" 0.25 0)))
    tia25Place(cv "analogLib" "res" "R2" 14 -3.25 list(list("r" "string" "1.6903k")) list(list("PLUS" "vdd" 0 0.25) list("MINUS" "x" 0 -0.25)))
    tia25Place(cv "gpdk090" "pmos1v" "Mp1" 17.5 -3.25 list(list("w" "string" "29.72u") list("fw" "string" "29.72u") list("l" "string" "100n") list("fingers" "string" "1") list("m" "string" "1")) list(list("D" "d1" 0 -0.25) list("G" "d1" -0.25 0) list("S" "vdd" 0 0.25) list("B" "vdd" 0.25 0)))
    tia25Place(cv "gpdk090" "pmos1v" "Mp2" 0 -6.5 list(list("w" "string" "35.51u") list("fw" "string" "35.51u") list("l" "string" "100n") list("fingers" "string" "1") list("m" "string" "1")) list(list("D" "out" 0 -0.25) list("G" "d1" -0.25 0) list("S" "vdd" 0 0.25) list("B" "vdd" 0.25 0)))
    tia25Place(cv "analogLib" "res" "RL" 3.5 -6.5 list(list("r" "string" "550.8")) list(list("PLUS" "out" 0 0.25) list("MINUS" "gnd!" 0 -0.25)))
    tia25Place(cv "gpdk090" "nmos1v" "M3" 7 -6.5 list(list("w" "string" "2.632u") list("fw" "string" "2.632u") list("l" "string" "100n") list("fingers" "string" "1") list("m" "string" "1")) list(list("D" "x" 0 0.25) list("G" "d1" -0.25 0) list("S" "s3" 0 -0.25) list("B" "gnd!" 0.25 0)))
    tia25Place(cv "analogLib" "res" "R3" 10.5 -6.5 list(list("r" "string" "1.5322k")) list(list("PLUS" "s3" 0 0.25) list("MINUS" "gnd!" 0 -0.25)))
    tia25Place(cv "analogLib" "cap" "C3" 14 -6.5 list(list("c" "string" "28.679f")) list(list("PLUS" "s3" 0 0.25) list("MINUS" "gnd!" 0 -0.25)))
    schCheck(cv) dbSave(cv) dbClose(cv) t))

;; Same, sized for the nominal corner only
procedure( tia25_var_cmnrc_nominal(lib)
  let( (cv)
    cv = dbOpenCellViewByType(lib "var_cmnrc_nominal" "schematic" "schematic" "w")
    tia25Place(cv "analogLib" "vdc" "Vdd" 0 0 list(list("vdc" "string" "1")) list(list("PLUS" "vdd" 0 0.25) list("MINUS" "gnd!" 0 -0.25)))
    tia25Place(cv "analogLib" "cap" "Cpd" 3.5 0 list(list("c" "string" "450f")) list(list("PLUS" "in" 0 0.25) list("MINUS" "gnd!" 0 -0.25)))
    tia25Place(cv "analogLib" "cap" "CL" 7 0 list(list("c" "string" "50f")) list(list("PLUS" "out" 0 0.25) list("MINUS" "gnd!" 0 -0.25)))
    tia25Place(cv "analogLib" "idc" "Iin" 10.5 0 list(list("idc" "string" "0") list("acm" "string" "1")) list(list("PLUS" "gnd!" 0 0.25) list("MINUS" "in" 0 -0.25)))
    tia25Place(cv "analogLib" "idc" "Ibn" 14 0 list(list("idc" "string" "20u")) list(list("PLUS" "vdd" 0 0.25) list("MINUS" "vbn" 0 -0.25)))
    tia25Place(cv "gpdk090" "nmos1v" "Mdn" 17.5 0 list(list("w" "string" "1u") list("fw" "string" "1u") list("l" "string" "200n") list("fingers" "string" "1") list("m" "string" "1")) list(list("D" "vbn" 0 0.25) list("G" "vbn" -0.25 0) list("S" "gnd!" 0 -0.25) list("B" "gnd!" 0.25 0)))
    tia25Place(cv "analogLib" "cap" "Cbn" 0 -3.25 list(list("c" "string" "2p")) list(list("PLUS" "vbn" 0 0.25) list("MINUS" "gnd!" 0 -0.25)))
    tia25Place(cv "gpdk090" "nmos1v" "Mb" 3.5 -3.25 list(list("w" "string" "4.696u") list("fw" "string" "4.696u") list("l" "string" "200n") list("fingers" "string" "1") list("m" "string" "1")) list(list("D" "in" 0 0.25) list("G" "vbn" -0.25 0) list("S" "gnd!" 0 -0.25) list("B" "gnd!" 0.25 0)))
    tia25Place(cv "gpdk090" "nmos1v" "M1" 7 -3.25 list(list("w" "string" "3.466u") list("fw" "string" "3.466u") list("l" "string" "100n") list("fingers" "string" "1") list("m" "string" "1")) list(list("D" "d1" 0 0.25) list("G" "x" -0.25 0) list("S" "in" 0 -0.25) list("B" "gnd!" 0.25 0)))
    tia25Place(cv "gpdk090" "nmos1v" "M2" 10.5 -3.25 list(list("w" "string" "13.91u") list("fw" "string" "13.91u") list("l" "string" "100n") list("fingers" "string" "1") list("m" "string" "1")) list(list("D" "x" 0 0.25) list("G" "in" -0.25 0) list("S" "gnd!" 0 -0.25) list("B" "gnd!" 0.25 0)))
    tia25Place(cv "analogLib" "res" "R2" 14 -3.25 list(list("r" "string" "773.68")) list(list("PLUS" "vdd" 0 0.25) list("MINUS" "x" 0 -0.25)))
    tia25Place(cv "gpdk090" "pmos1v" "Mp1" 17.5 -3.25 list(list("w" "string" "2.981u") list("fw" "string" "2.981u") list("l" "string" "100n") list("fingers" "string" "1") list("m" "string" "1")) list(list("D" "d1" 0 -0.25) list("G" "d1" -0.25 0) list("S" "vdd" 0 0.25) list("B" "vdd" 0.25 0)))
    tia25Place(cv "gpdk090" "pmos1v" "Mp2" 0 -6.5 list(list("w" "string" "12.66u") list("fw" "string" "12.66u") list("l" "string" "100n") list("fingers" "string" "1") list("m" "string" "1")) list(list("D" "out" 0 -0.25) list("G" "d1" -0.25 0) list("S" "vdd" 0 0.25) list("B" "vdd" 0.25 0)))
    tia25Place(cv "analogLib" "res" "RL" 3.5 -6.5 list(list("r" "string" "1.8007k")) list(list("PLUS" "out" 0 0.25) list("MINUS" "gnd!" 0 -0.25)))
    tia25Place(cv "gpdk090" "nmos1v" "M3" 7 -6.5 list(list("w" "string" "3.391u") list("fw" "string" "3.391u") list("l" "string" "100n") list("fingers" "string" "1") list("m" "string" "1")) list(list("D" "x" 0 0.25) list("G" "d1" -0.25 0) list("S" "s3" 0 -0.25) list("B" "gnd!" 0.25 0)))
    tia25Place(cv "analogLib" "res" "R3" 10.5 -6.5 list(list("r" "string" "618.23")) list(list("PLUS" "s3" 0 0.25) list("MINUS" "gnd!" 0 -0.25)))
    tia25Place(cv "analogLib" "cap" "C3" 14 -6.5 list(list("c" "string" "214.36f")) list(list("PLUS" "s3" 0 0.25) list("MINUS" "gnd!" 0 -0.25)))
    schCheck(cv) dbSave(cv) dbClose(cv) t))

;; RGC with PMOS current-mirror output (no negative-RC path)
procedure( tia25_var_cmrgc_robust(lib)
  let( (cv)
    cv = dbOpenCellViewByType(lib "var_cmrgc_robust" "schematic" "schematic" "w")
    tia25Place(cv "analogLib" "vdc" "Vdd" 0 0 list(list("vdc" "string" "1")) list(list("PLUS" "vdd" 0 0.25) list("MINUS" "gnd!" 0 -0.25)))
    tia25Place(cv "analogLib" "cap" "Cpd" 3.5 0 list(list("c" "string" "450f")) list(list("PLUS" "in" 0 0.25) list("MINUS" "gnd!" 0 -0.25)))
    tia25Place(cv "analogLib" "cap" "CL" 7 0 list(list("c" "string" "50f")) list(list("PLUS" "out" 0 0.25) list("MINUS" "gnd!" 0 -0.25)))
    tia25Place(cv "analogLib" "idc" "Iin" 10.5 0 list(list("idc" "string" "0") list("acm" "string" "1")) list(list("PLUS" "gnd!" 0 0.25) list("MINUS" "in" 0 -0.25)))
    tia25Place(cv "analogLib" "idc" "Ibn" 14 0 list(list("idc" "string" "20u")) list(list("PLUS" "vdd" 0 0.25) list("MINUS" "vbn" 0 -0.25)))
    tia25Place(cv "gpdk090" "nmos1v" "Mdn" 17.5 0 list(list("w" "string" "1u") list("fw" "string" "1u") list("l" "string" "200n") list("fingers" "string" "1") list("m" "string" "1")) list(list("D" "vbn" 0 0.25) list("G" "vbn" -0.25 0) list("S" "gnd!" 0 -0.25) list("B" "gnd!" 0.25 0)))
    tia25Place(cv "analogLib" "cap" "Cbn" 0 -3.25 list(list("c" "string" "2p")) list(list("PLUS" "vbn" 0 0.25) list("MINUS" "gnd!" 0 -0.25)))
    tia25Place(cv "gpdk090" "nmos1v" "Mb" 3.5 -3.25 list(list("w" "string" "17.06u") list("fw" "string" "17.06u") list("l" "string" "200n") list("fingers" "string" "1") list("m" "string" "1")) list(list("D" "in" 0 0.25) list("G" "vbn" -0.25 0) list("S" "gnd!" 0 -0.25) list("B" "gnd!" 0.25 0)))
    tia25Place(cv "gpdk090" "nmos1v" "M1" 7 -3.25 list(list("w" "string" "27.2u") list("fw" "string" "27.2u") list("l" "string" "100n") list("fingers" "string" "1") list("m" "string" "1")) list(list("D" "d1" 0 0.25) list("G" "x" -0.25 0) list("S" "in" 0 -0.25) list("B" "gnd!" 0.25 0)))
    tia25Place(cv "gpdk090" "nmos1v" "M2" 10.5 -3.25 list(list("w" "string" "20.18u") list("fw" "string" "20.18u") list("l" "string" "100n") list("fingers" "string" "1") list("m" "string" "1")) list(list("D" "x" 0 0.25) list("G" "in" -0.25 0) list("S" "gnd!" 0 -0.25) list("B" "gnd!" 0.25 0)))
    tia25Place(cv "analogLib" "res" "R2" 14 -3.25 list(list("r" "string" "1.4867k")) list(list("PLUS" "vdd" 0 0.25) list("MINUS" "x" 0 -0.25)))
    tia25Place(cv "gpdk090" "pmos1v" "Mp1" 17.5 -3.25 list(list("w" "string" "37.34u") list("fw" "string" "37.34u") list("l" "string" "100n") list("fingers" "string" "1") list("m" "string" "1")) list(list("D" "d1" 0 -0.25) list("G" "d1" -0.25 0) list("S" "vdd" 0 0.25) list("B" "vdd" 0.25 0)))
    tia25Place(cv "gpdk090" "pmos1v" "Mp2" 0 -6.5 list(list("w" "string" "38.84u") list("fw" "string" "38.84u") list("l" "string" "100n") list("fingers" "string" "1") list("m" "string" "1")) list(list("D" "out" 0 -0.25) list("G" "d1" -0.25 0) list("S" "vdd" 0 0.25) list("B" "vdd" 0.25 0)))
    tia25Place(cv "analogLib" "res" "RL" 3.5 -6.5 list(list("r" "string" "285.06")) list(list("PLUS" "out" 0 0.25) list("MINUS" "gnd!" 0 -0.25)))
    schCheck(cv) dbSave(cv) dbClose(cv) t))

;; Current-mirror TIA, shunt feedback, passive shunt-peaking inductor - reconstruction
procedure( tia25_ref_shaaban_L(lib)
  let( (cv)
    cv = dbOpenCellViewByType(lib "ref_shaaban_L" "schematic" "schematic" "w")
    tia25Place(cv "analogLib" "vdc" "Vdd" 0 0 list(list("vdc" "string" "1")) list(list("PLUS" "vdd" 0 0.25) list("MINUS" "gnd!" 0 -0.25)))
    tia25Place(cv "analogLib" "cap" "Cpd" 3.5 0 list(list("c" "string" "450f")) list(list("PLUS" "in" 0 0.25) list("MINUS" "gnd!" 0 -0.25)))
    tia25Place(cv "analogLib" "cap" "CL" 7 0 list(list("c" "string" "50f")) list(list("PLUS" "out" 0 0.25) list("MINUS" "gnd!" 0 -0.25)))
    tia25Place(cv "analogLib" "idc" "Iin" 10.5 0 list(list("idc" "string" "0") list("acm" "string" "1")) list(list("PLUS" "gnd!" 0 0.25) list("MINUS" "in" 0 -0.25)))
    tia25Place(cv "analogLib" "idc" "Ibp" 14 0 list(list("idc" "string" "20u")) list(list("PLUS" "vbp" 0 0.25) list("MINUS" "gnd!" 0 -0.25)))
    tia25Place(cv "gpdk090" "pmos1v" "Mdp" 17.5 0 list(list("w" "string" "2u") list("fw" "string" "2u") list("l" "string" "200n") list("fingers" "string" "1") list("m" "string" "1")) list(list("D" "vbp" 0 -0.25) list("G" "vbp" -0.25 0) list("S" "vdd" 0 0.25) list("B" "vdd" 0.25 0)))
    tia25Place(cv "analogLib" "cap" "Cbp" 0 -3.25 list(list("c" "string" "2p")) list(list("PLUS" "vbp" 0 0.25) list("MINUS" "vdd" 0 -0.25)))
    tia25Place(cv "gpdk090" "pmos1v" "Mp1" 3.5 -3.25 list(list("w" "string" "4.169u") list("fw" "string" "4.169u") list("l" "string" "200n") list("fingers" "string" "1") list("m" "string" "1")) list(list("D" "in" 0 -0.25) list("G" "vbp" -0.25 0) list("S" "vdd" 0 0.25) list("B" "vdd" 0.25 0)))
    tia25Place(cv "gpdk090" "nmos1v" "M1" 7 -3.25 list(list("w" "string" "2.395u") list("fw" "string" "2.395u") list("l" "string" "100n") list("fingers" "string" "1") list("m" "string" "1")) list(list("D" "in" 0 0.25) list("G" "in" -0.25 0) list("S" "gnd!" 0 -0.25) list("B" "gnd!" 0.25 0)))
    tia25Place(cv "gpdk090" "nmos1v" "M2" 10.5 -3.25 list(list("w" "string" "24.53u") list("fw" "string" "24.53u") list("l" "string" "100n") list("fingers" "string" "1") list("m" "string" "1")) list(list("D" "out" 0 0.25) list("G" "in" -0.25 0) list("S" "gnd!" 0 -0.25) list("B" "gnd!" 0.25 0)))
    tia25Place(cv "analogLib" "res" "Rf" 14 -3.25 list(list("r" "string" "9.011k")) list(list("PLUS" "out" 0 0.25) list("MINUS" "in" 0 -0.25)))
    tia25Place(cv "analogLib" "res" "RL" 17.5 -3.25 list(list("r" "string" "89.223")) list(list("PLUS" "vdd" 0 0.25) list("MINUS" "lx" 0 -0.25)))
    tia25Place(cv "analogLib" "ind" "Lp" 0 -6.5 list(list("l" "string" "17.843n")) list(list("PLUS" "lx" 0 0.25) list("MINUS" "out" 0 -0.25)))
    schCheck(cv) dbSave(cv) dbClose(cv) t))

;; Current-mirror TIA with NMOS source-follower active inductor - reconstruction
procedure( tia25_ref_shaaban_AN(lib)
  let( (cv)
    cv = dbOpenCellViewByType(lib "ref_shaaban_AN" "schematic" "schematic" "w")
    tia25Place(cv "analogLib" "vdc" "Vdd" 0 0 list(list("vdc" "string" "1")) list(list("PLUS" "vdd" 0 0.25) list("MINUS" "gnd!" 0 -0.25)))
    tia25Place(cv "analogLib" "cap" "Cpd" 3.5 0 list(list("c" "string" "450f")) list(list("PLUS" "in" 0 0.25) list("MINUS" "gnd!" 0 -0.25)))
    tia25Place(cv "analogLib" "cap" "CL" 7 0 list(list("c" "string" "50f")) list(list("PLUS" "out" 0 0.25) list("MINUS" "gnd!" 0 -0.25)))
    tia25Place(cv "analogLib" "idc" "Iin" 10.5 0 list(list("idc" "string" "0") list("acm" "string" "1")) list(list("PLUS" "gnd!" 0 0.25) list("MINUS" "in" 0 -0.25)))
    tia25Place(cv "analogLib" "idc" "Ibp" 14 0 list(list("idc" "string" "20u")) list(list("PLUS" "vbp" 0 0.25) list("MINUS" "gnd!" 0 -0.25)))
    tia25Place(cv "gpdk090" "pmos1v" "Mdp" 17.5 0 list(list("w" "string" "2u") list("fw" "string" "2u") list("l" "string" "200n") list("fingers" "string" "1") list("m" "string" "1")) list(list("D" "vbp" 0 -0.25) list("G" "vbp" -0.25 0) list("S" "vdd" 0 0.25) list("B" "vdd" 0.25 0)))
    tia25Place(cv "analogLib" "cap" "Cbp" 0 -3.25 list(list("c" "string" "2p")) list(list("PLUS" "vbp" 0 0.25) list("MINUS" "vdd" 0 -0.25)))
    tia25Place(cv "gpdk090" "pmos1v" "Mp1" 3.5 -3.25 list(list("w" "string" "37.58u") list("fw" "string" "37.58u") list("l" "string" "200n") list("fingers" "string" "1") list("m" "string" "1")) list(list("D" "in" 0 -0.25) list("G" "vbp" -0.25 0) list("S" "vdd" 0 0.25) list("B" "vdd" 0.25 0)))
    tia25Place(cv "gpdk090" "nmos1v" "M1" 7 -3.25 list(list("w" "string" "7.45u") list("fw" "string" "7.45u") list("l" "string" "100n") list("fingers" "string" "1") list("m" "string" "1")) list(list("D" "in" 0 0.25) list("G" "in" -0.25 0) list("S" "gnd!" 0 -0.25) list("B" "gnd!" 0.25 0)))
    tia25Place(cv "gpdk090" "nmos1v" "M2" 10.5 -3.25 list(list("w" "string" "23.22u") list("fw" "string" "23.22u") list("l" "string" "100n") list("fingers" "string" "1") list("m" "string" "1")) list(list("D" "out" 0 0.25) list("G" "in" -0.25 0) list("S" "gnd!" 0 -0.25) list("B" "gnd!" 0.25 0)))
    tia25Place(cv "analogLib" "res" "Rf" 14 -3.25 list(list("r" "string" "8.4054k")) list(list("PLUS" "out" 0 0.25) list("MINUS" "in" 0 -0.25)))
    tia25Place(cv "gpdk090" "nmos1v" "Ma" 17.5 -3.25 list(list("w" "string" "2.032u") list("fw" "string" "2.032u") list("l" "string" "100n") list("fingers" "string" "1") list("m" "string" "1")) list(list("D" "vdd" 0 0.25) list("G" "ga" -0.25 0) list("S" "out" 0 -0.25) list("B" "gnd!" 0.25 0)))
    tia25Place(cv "analogLib" "res" "Rg" 0 -6.5 list(list("r" "string" "53.21k")) list(list("PLUS" "vdd" 0 0.25) list("MINUS" "ga" 0 -0.25)))
    schCheck(cv) dbSave(cv) dbClose(cv) t))

;; Current-mirror TIA with PMOS gate-resistor active inductor - reconstruction
procedure( tia25_ref_shaaban_AP(lib)
  let( (cv)
    cv = dbOpenCellViewByType(lib "ref_shaaban_AP" "schematic" "schematic" "w")
    tia25Place(cv "analogLib" "vdc" "Vdd" 0 0 list(list("vdc" "string" "1")) list(list("PLUS" "vdd" 0 0.25) list("MINUS" "gnd!" 0 -0.25)))
    tia25Place(cv "analogLib" "cap" "Cpd" 3.5 0 list(list("c" "string" "450f")) list(list("PLUS" "in" 0 0.25) list("MINUS" "gnd!" 0 -0.25)))
    tia25Place(cv "analogLib" "cap" "CL" 7 0 list(list("c" "string" "50f")) list(list("PLUS" "out" 0 0.25) list("MINUS" "gnd!" 0 -0.25)))
    tia25Place(cv "analogLib" "idc" "Iin" 10.5 0 list(list("idc" "string" "0") list("acm" "string" "1")) list(list("PLUS" "gnd!" 0 0.25) list("MINUS" "in" 0 -0.25)))
    tia25Place(cv "analogLib" "idc" "Ibp" 14 0 list(list("idc" "string" "20u")) list(list("PLUS" "vbp" 0 0.25) list("MINUS" "gnd!" 0 -0.25)))
    tia25Place(cv "gpdk090" "pmos1v" "Mdp" 17.5 0 list(list("w" "string" "2u") list("fw" "string" "2u") list("l" "string" "200n") list("fingers" "string" "1") list("m" "string" "1")) list(list("D" "vbp" 0 -0.25) list("G" "vbp" -0.25 0) list("S" "vdd" 0 0.25) list("B" "vdd" 0.25 0)))
    tia25Place(cv "analogLib" "cap" "Cbp" 0 -3.25 list(list("c" "string" "2p")) list(list("PLUS" "vbp" 0 0.25) list("MINUS" "vdd" 0 -0.25)))
    tia25Place(cv "gpdk090" "pmos1v" "Mp1" 3.5 -3.25 list(list("w" "string" "29.84u") list("fw" "string" "29.84u") list("l" "string" "200n") list("fingers" "string" "1") list("m" "string" "1")) list(list("D" "in" 0 -0.25) list("G" "vbp" -0.25 0) list("S" "vdd" 0 0.25) list("B" "vdd" 0.25 0)))
    tia25Place(cv "gpdk090" "nmos1v" "M1" 7 -3.25 list(list("w" "string" "5.591u") list("fw" "string" "5.591u") list("l" "string" "100n") list("fingers" "string" "1") list("m" "string" "1")) list(list("D" "in" 0 0.25) list("G" "in" -0.25 0) list("S" "gnd!" 0 -0.25) list("B" "gnd!" 0.25 0)))
    tia25Place(cv "gpdk090" "nmos1v" "M2" 10.5 -3.25 list(list("w" "string" "20.22u") list("fw" "string" "20.22u") list("l" "string" "100n") list("fingers" "string" "1") list("m" "string" "1")) list(list("D" "out" 0 0.25) list("G" "in" -0.25 0) list("S" "gnd!" 0 -0.25) list("B" "gnd!" 0.25 0)))
    tia25Place(cv "analogLib" "res" "Rf" 14 -3.25 list(list("r" "string" "19.217k")) list(list("PLUS" "out" 0 0.25) list("MINUS" "in" 0 -0.25)))
    tia25Place(cv "gpdk090" "pmos1v" "Ma" 17.5 -3.25 list(list("w" "string" "7.568u") list("fw" "string" "7.568u") list("l" "string" "100n") list("fingers" "string" "1") list("m" "string" "1")) list(list("D" "out" 0 -0.25) list("G" "ga" -0.25 0) list("S" "vdd" 0 0.25) list("B" "vdd" 0.25 0)))
    tia25Place(cv "analogLib" "res" "Rg" 0 -6.5 list(list("r" "string" "13.553k")) list(list("PLUS" "ga" 0 0.25) list("MINUS" "out" 0 -0.25)))
    tia25Place(cv "analogLib" "res" "RL" 3.5 -6.5 list(list("r" "string" "101.51k")) list(list("PLUS" "vdd" 0 0.25) list("MINUS" "out" 0 -0.25)))
    schCheck(cv) dbSave(cv) dbClose(cv) t))

;; PF-TIA re-sized under the same rules
procedure( tia25_ref_pftia_earlier(lib)
  let( (cv)
    cv = dbOpenCellViewByType(lib "ref_pftia_earlier" "schematic" "schematic" "w")
    tia25Place(cv "analogLib" "vdc" "Vdd" 0 0 list(list("vdc" "string" "1")) list(list("PLUS" "vdd" 0 0.25) list("MINUS" "gnd!" 0 -0.25)))
    tia25Place(cv "analogLib" "cap" "Cpd" 3.5 0 list(list("c" "string" "450f")) list(list("PLUS" "in" 0 0.25) list("MINUS" "gnd!" 0 -0.25)))
    tia25Place(cv "analogLib" "cap" "CL" 7 0 list(list("c" "string" "50f")) list(list("PLUS" "out" 0 0.25) list("MINUS" "gnd!" 0 -0.25)))
    tia25Place(cv "analogLib" "idc" "Iin" 10.5 0 list(list("idc" "string" "0") list("acm" "string" "1")) list(list("PLUS" "gnd!" 0 0.25) list("MINUS" "in" 0 -0.25)))
    tia25Place(cv "analogLib" "idc" "Ibp" 14 0 list(list("idc" "string" "20u")) list(list("PLUS" "vbp" 0 0.25) list("MINUS" "gnd!" 0 -0.25)))
    tia25Place(cv "gpdk090" "pmos1v" "Mdp" 17.5 0 list(list("w" "string" "2u") list("fw" "string" "2u") list("l" "string" "200n") list("fingers" "string" "1") list("m" "string" "1")) list(list("D" "vbp" 0 -0.25) list("G" "vbp" -0.25 0) list("S" "vdd" 0 0.25) list("B" "vdd" 0.25 0)))
    tia25Place(cv "analogLib" "cap" "Cbp" 0 -3.25 list(list("c" "string" "2p")) list(list("PLUS" "vbp" 0 0.25) list("MINUS" "vdd" 0 -0.25)))
    tia25Place(cv "analogLib" "vdc" "Vb1" 3.5 -3.25 list(list("vdc" "string" "543.61m")) list(list("PLUS" "vb1" 0 0.25) list("MINUS" "gnd!" 0 -0.25)))
    tia25Place(cv "analogLib" "res" "Rn" 7 -3.25 list(list("r" "string" "7.2148k")) list(list("PLUS" "vdd" 0 0.25) list("MINUS" "n" 0 -0.25)))
    tia25Place(cv "gpdk090" "nmos1v" "M1" 10.5 -3.25 list(list("w" "string" "3.618u") list("fw" "string" "3.618u") list("l" "string" "100n") list("fingers" "string" "1") list("m" "string" "1")) list(list("D" "n" 0 0.25) list("G" "vb1" -0.25 0) list("S" "in" 0 -0.25) list("B" "gnd!" 0.25 0)))
    tia25Place(cv "gpdk090" "nmos1v" "M2" 14 -3.25 list(list("w" "string" "2.682u") list("fw" "string" "2.682u") list("l" "string" "100n") list("fingers" "string" "1") list("m" "string" "1")) list(list("D" "in" 0 0.25) list("G" "n" -0.25 0) list("S" "gnd!" 0 -0.25) list("B" "gnd!" 0.25 0)))
    tia25Place(cv "gpdk090" "nmos1v" "M3" 17.5 -3.25 list(list("w" "string" "5.352u") list("fw" "string" "5.352u") list("l" "string" "100n") list("fingers" "string" "1") list("m" "string" "1")) list(list("D" "out" 0 0.25) list("G" "n" -0.25 0) list("S" "gnd!" 0 -0.25) list("B" "gnd!" 0.25 0)))
    tia25Place(cv "gpdk090" "pmos1v" "M3b" 0 -6.5 list(list("w" "string" "27.28u") list("fw" "string" "27.28u") list("l" "string" "200n") list("fingers" "string" "1") list("m" "string" "1")) list(list("D" "out" 0 -0.25) list("G" "vbp" -0.25 0) list("S" "vdd" 0 0.25) list("B" "vdd" 0.25 0)))
    tia25Place(cv "gpdk090" "nmos1v" "Mf" 3.5 -6.5 list(list("w" "string" "1.268u") list("fw" "string" "1.268u") list("l" "string" "100n") list("fingers" "string" "1") list("m" "string" "1")) list(list("D" "vdd" 0 0.25) list("G" "out" -0.25 0) list("S" "in" 0 -0.25) list("B" "gnd!" 0.25 0)))
    schCheck(cv) dbSave(cv) dbClose(cv) t))

procedure( tia25BuildAll(lib) tia25_base_mdfrgc_robust(lib) tia25_base_mdfrgc_nominal(lib) tia25_ref_rgc_robust(lib) tia25_prop_mdfrgc_trim(lib) tia25_var_cmnrc_robust(lib) tia25_var_cmnrc_nominal(lib) tia25_var_cmrgc_robust(lib) tia25_ref_shaaban_L(lib) tia25_ref_shaaban_AN(lib) tia25_ref_shaaban_AP(lib) tia25_ref_pftia_earlier(lib) )
